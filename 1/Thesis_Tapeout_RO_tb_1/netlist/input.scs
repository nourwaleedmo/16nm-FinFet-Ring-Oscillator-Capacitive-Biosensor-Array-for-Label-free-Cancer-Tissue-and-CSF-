// Design: Thesis_Tapeout/RO_tb
simulator lang=spectre
global 0
parameters temperature=27
include "/eda/cadence/FFC_UNIV/pdk/TN16CRSP012W1_1_1_1P1A/iPDK_GEN2_CRN16FFCLL_v1.1_1p1a_20190628_all/iPDK_CRN16FFCLL_v1.1_1p1a_20190628_all/iPDK_CRN16FFCLL_v1.1_1p1a_20190628/tsmcN16/../models/toplevel.scs" section=top_tt

// Thesis_4/invter_digital/schematic
subckt invter_digital IN OUT VDD VDD_G VSS VSS_G
    M2 (OUT IN VDD_G VDD) pch_ulvt_mac l=16.0n nfin=5 w=202.00n multi=1 nf=1 sd=74.0n sa=90n sb=90n ploda1=16.0n ploda2=0 ploda3=0 plodb1=16.0n plodb2=0 plodb3=0 nf_flag=1 smbt=1M smbb=1M dinsaflag=0 ppitch=0 spot=35.0n spob=182.00n spotl1=35.0n spobl1=182.00n spotl2=35.0n spobl2=182.00n spotr1=35.0n spobr1=182.00n spotr2=35.0n spobr2=182.00n
    M1 (OUT IN VSS_G VSS) nch_ulvt_mac l=16.0n nfin=5 w=202.00n multi=1 nf=1 sd=74.0n sa=90n sb=90n ploda1=16.0n ploda2=0 ploda3=0 plodb1=16.0n plodb2=0 plodb3=0 nf_flag=1 smbt=1M smbb=1M dinsaflag=0 ppitch=0 spot=166n spob=35n spotl1=166n spobl1=35n spotl2=166n spobl2=35n spotr1=166n spobr1=35n spotr2=166n spobr2=35n
ends invter_digital

// tcbn16ffcllbwp16p90/BUFFD14BWP16P90/schematic
subckt BUFFD14BWP16P90 I Z VDD VSS VPP VBB
    MM21_5 (net58 I VDD VPP) pch_svt_mac l=16.0n nfin=4 w=154.00n multi=1 nf=1 sd=74.0n sa=90n sb=90n ploda1=16.0n ploda2=0 ploda3=0 plodb1=16.0n plodb2=0 plodb3=0 nf_flag=1 smbt=1M smbb=1M dinsaflag=0 ppitch=0 spot=103.00n spob=103.00n spotl1=103.00n spobl1=103.00n spotl2=103.00n spobl2=103.00n spotr1=103.00n spobr1=103.00n spotr2=103.00n spobr2=103.00n
    MM20_14 (Z net58 VDD VPP) pch_svt_mac l=16.0n nfin=4 w=154.00n multi=1 nf=1 sd=74.0n sa=90n sb=90n ploda1=16.0n ploda2=0 ploda3=0 plodb1=16.0n plodb2=0 plodb3=0 nf_flag=1 smbt=1M smbb=1M dinsaflag=0 ppitch=0 spot=103.00n spob=103.00n spotl1=103.00n spobl1=103.00n spotl2=103.00n spobl2=103.00n spotr1=103.00n spobr1=103.00n spotr2=103.00n spobr2=103.00n
    MM21_1 (net58 I VDD VPP) pch_svt_mac l=16.0n nfin=4 w=154.00n multi=1 nf=1 sd=74.0n sa=90n sb=90n ploda1=16.0n ploda2=0 ploda3=0 plodb1=16.0n plodb2=0 plodb3=0 nf_flag=1 smbt=1M smbb=1M dinsaflag=0 ppitch=0 spot=103.00n spob=103.00n spotl1=103.00n spobl1=103.00n spotl2=103.00n spobl2=103.00n spotr1=103.00n spobr1=103.00n spotr2=103.00n spobr2=103.00n
    MM21_2 (net58 I VDD VPP) pch_svt_mac l=16.0n nfin=4 w=154.00n multi=1 nf=1 sd=74.0n sa=90n sb=90n ploda1=16.0n ploda2=0 ploda3=0 plodb1=16.0n plodb2=0 plodb3=0 nf_flag=1 smbt=1M smbb=1M dinsaflag=0 ppitch=0 spot=103.00n spob=103.00n spotl1=103.00n spobl1=103.00n spotl2=103.00n spobl2=103.00n spotr1=103.00n spobr1=103.00n spotr2=103.00n spobr2=103.00n
    MM20_8 (Z net58 VDD VPP) pch_svt_mac l=16.0n nfin=4 w=154.00n multi=1 nf=1 sd=74.0n sa=90n sb=90n ploda1=16.0n ploda2=0 ploda3=0 plodb1=16.0n plodb2=0 plodb3=0 nf_flag=1 smbt=1M smbb=1M dinsaflag=0 ppitch=0 spot=103.00n spob=103.00n spotl1=103.00n spobl1=103.00n spotl2=103.00n spobl2=103.00n spotr1=103.00n spobr1=103.00n spotr2=103.00n spobr2=103.00n
    MM20_6 (Z net58 VDD VPP) pch_svt_mac l=16.0n nfin=4 w=154.00n multi=1 nf=1 sd=74.0n sa=90n sb=90n ploda1=16.0n ploda2=0 ploda3=0 plodb1=16.0n plodb2=0 plodb3=0 nf_flag=1 smbt=1M smbb=1M dinsaflag=0 ppitch=0 spot=103.00n spob=103.00n spotl1=103.00n spobl1=103.00n spotl2=103.00n spobl2=103.00n spotr1=103.00n spobr1=103.00n spotr2=103.00n spobr2=103.00n
    MM20_7 (Z net58 VDD VPP) pch_svt_mac l=16.0n nfin=4 w=154.00n multi=1 nf=1 sd=74.0n sa=90n sb=90n ploda1=16.0n ploda2=0 ploda3=0 plodb1=16.0n plodb2=0 plodb3=0 nf_flag=1 smbt=1M smbb=1M dinsaflag=0 ppitch=0 spot=103.00n spob=103.00n spotl1=103.00n spobl1=103.00n spotl2=103.00n spobl2=103.00n spotr1=103.00n spobr1=103.00n spotr2=103.00n spobr2=103.00n
    MM20_12 (Z net58 VDD VPP) pch_svt_mac l=16.0n nfin=4 w=154.00n multi=1 nf=1 sd=74.0n sa=90n sb=90n ploda1=16.0n ploda2=0 ploda3=0 plodb1=16.0n plodb2=0 plodb3=0 nf_flag=1 smbt=1M smbb=1M dinsaflag=0 ppitch=0 spot=103.00n spob=103.00n spotl1=103.00n spobl1=103.00n spotl2=103.00n spobl2=103.00n spotr1=103.00n spobr1=103.00n spotr2=103.00n spobr2=103.00n
    MM20_2 (Z net58 VDD VPP) pch_svt_mac l=16.0n nfin=4 w=154.00n multi=1 nf=1 sd=74.0n sa=90n sb=90n ploda1=16.0n ploda2=0 ploda3=0 plodb1=16.0n plodb2=0 plodb3=0 nf_flag=1 smbt=1M smbb=1M dinsaflag=0 ppitch=0 spot=103.00n spob=103.00n spotl1=103.00n spobl1=103.00n spotl2=103.00n spobl2=103.00n spotr1=103.00n spobr1=103.00n spotr2=103.00n spobr2=103.00n
    MM20_3 (Z net58 VDD VPP) pch_svt_mac l=16.0n nfin=4 w=154.00n multi=1 nf=1 sd=74.0n sa=90n sb=90n ploda1=16.0n ploda2=0 ploda3=0 plodb1=16.0n plodb2=0 plodb3=0 nf_flag=1 smbt=1M smbb=1M dinsaflag=0 ppitch=0 spot=103.00n spob=103.00n spotl1=103.00n spobl1=103.00n spotl2=103.00n spobl2=103.00n spotr1=103.00n spobr1=103.00n spotr2=103.00n spobr2=103.00n
    MM20_5 (Z net58 VDD VPP) pch_svt_mac l=16.0n nfin=4 w=154.00n multi=1 nf=1 sd=74.0n sa=90n sb=90n ploda1=16.0n ploda2=0 ploda3=0 plodb1=16.0n plodb2=0 plodb3=0 nf_flag=1 smbt=1M smbb=1M dinsaflag=0 ppitch=0 spot=103.00n spob=103.00n spotl1=103.00n spobl1=103.00n spotl2=103.00n spobl2=103.00n spotr1=103.00n spobr1=103.00n spotr2=103.00n spobr2=103.00n
    MM20_11 (Z net58 VDD VPP) pch_svt_mac l=16.0n nfin=4 w=154.00n multi=1 nf=1 sd=74.0n sa=90n sb=90n ploda1=16.0n ploda2=0 ploda3=0 plodb1=16.0n plodb2=0 plodb3=0 nf_flag=1 smbt=1M smbb=1M dinsaflag=0 ppitch=0 spot=103.00n spob=103.00n spotl1=103.00n spobl1=103.00n spotl2=103.00n spobl2=103.00n spotr1=103.00n spobr1=103.00n spotr2=103.00n spobr2=103.00n
    MM20_9 (Z net58 VDD VPP) pch_svt_mac l=16.0n nfin=4 w=154.00n multi=1 nf=1 sd=74.0n sa=90n sb=90n ploda1=16.0n ploda2=0 ploda3=0 plodb1=16.0n plodb2=0 plodb3=0 nf_flag=1 smbt=1M smbb=1M dinsaflag=0 ppitch=0 spot=103.00n spob=103.00n spotl1=103.00n spobl1=103.00n spotl2=103.00n spobl2=103.00n spotr1=103.00n spobr1=103.00n spotr2=103.00n spobr2=103.00n
    MM20_4 (Z net58 VDD VPP) pch_svt_mac l=16.0n nfin=4 w=154.00n multi=1 nf=1 sd=74.0n sa=90n sb=90n ploda1=16.0n ploda2=0 ploda3=0 plodb1=16.0n plodb2=0 plodb3=0 nf_flag=1 smbt=1M smbb=1M dinsaflag=0 ppitch=0 spot=103.00n spob=103.00n spotl1=103.00n spobl1=103.00n spotl2=103.00n spobl2=103.00n spotr1=103.00n spobr1=103.00n spotr2=103.00n spobr2=103.00n
    MM20_13 (Z net58 VDD VPP) pch_svt_mac l=16.0n nfin=4 w=154.00n multi=1 nf=1 sd=74.0n sa=90n sb=90n ploda1=16.0n ploda2=0 ploda3=0 plodb1=16.0n plodb2=0 plodb3=0 nf_flag=1 smbt=1M smbb=1M dinsaflag=0 ppitch=0 spot=103.00n spob=103.00n spotl1=103.00n spobl1=103.00n spotl2=103.00n spobl2=103.00n spotr1=103.00n spobr1=103.00n spotr2=103.00n spobr2=103.00n
    MM21_4 (net58 I VDD VPP) pch_svt_mac l=16.0n nfin=4 w=154.00n multi=1 nf=1 sd=74.0n sa=90n sb=90n ploda1=16.0n ploda2=0 ploda3=0 plodb1=16.0n plodb2=0 plodb3=0 nf_flag=1 smbt=1M smbb=1M dinsaflag=0 ppitch=0 spot=103.00n spob=103.00n spotl1=103.00n spobl1=103.00n spotl2=103.00n spobl2=103.00n spotr1=103.00n spobr1=103.00n spotr2=103.00n spobr2=103.00n
    MM20_10 (Z net58 VDD VPP) pch_svt_mac l=16.0n nfin=4 w=154.00n multi=1 nf=1 sd=74.0n sa=90n sb=90n ploda1=16.0n ploda2=0 ploda3=0 plodb1=16.0n plodb2=0 plodb3=0 nf_flag=1 smbt=1M smbb=1M dinsaflag=0 ppitch=0 spot=103.00n spob=103.00n spotl1=103.00n spobl1=103.00n spotl2=103.00n spobl2=103.00n spotr1=103.00n spobr1=103.00n spotr2=103.00n spobr2=103.00n
    MM21_3 (net58 I VDD VPP) pch_svt_mac l=16.0n nfin=4 w=154.00n multi=1 nf=1 sd=74.0n sa=90n sb=90n ploda1=16.0n ploda2=0 ploda3=0 plodb1=16.0n plodb2=0 plodb3=0 nf_flag=1 smbt=1M smbb=1M dinsaflag=0 ppitch=0 spot=103.00n spob=103.00n spotl1=103.00n spobl1=103.00n spotl2=103.00n spobl2=103.00n spotr1=103.00n spobr1=103.00n spotr2=103.00n spobr2=103.00n
    MM20_1 (Z net58 VDD VPP) pch_svt_mac l=16.0n nfin=4 w=154.00n multi=1 nf=1 sd=74.0n sa=90n sb=90n ploda1=16.0n ploda2=0 ploda3=0 plodb1=16.0n plodb2=0 plodb3=0 nf_flag=1 smbt=1M smbb=1M dinsaflag=0 ppitch=0 spot=103.00n spob=103.00n spotl1=103.00n spobl1=103.00n spotl2=103.00n spobl2=103.00n spotr1=103.00n spobr1=103.00n spotr2=103.00n spobr2=103.00n
    MM0_14 (Z net58 VSS VBB) nch_svt_mac l=16.0n nfin=4 w=154.00n multi=1 nf=1 sd=74.0n sa=90n sb=90n ploda1=16.0n ploda2=0 ploda3=0 plodb1=16.0n plodb2=0 plodb3=0 nf_flag=1 smbt=1M smbb=1M dinsaflag=0 ppitch=0 spot=103.00n spob=103.00n spotl1=103.00n spobl1=103.00n spotl2=103.00n spobl2=103.00n spotr1=103.00n spobr1=103.00n spotr2=103.00n spobr2=103.00n
    MM0_10 (Z net58 VSS VBB) nch_svt_mac l=16.0n nfin=4 w=154.00n multi=1 nf=1 sd=74.0n sa=90n sb=90n ploda1=16.0n ploda2=0 ploda3=0 plodb1=16.0n plodb2=0 plodb3=0 nf_flag=1 smbt=1M smbb=1M dinsaflag=0 ppitch=0 spot=103.00n spob=103.00n spotl1=103.00n spobl1=103.00n spotl2=103.00n spobl2=103.00n spotr1=103.00n spobr1=103.00n spotr2=103.00n spobr2=103.00n
    MM0_7 (Z net58 VSS VBB) nch_svt_mac l=16.0n nfin=4 w=154.00n multi=1 nf=1 sd=74.0n sa=90n sb=90n ploda1=16.0n ploda2=0 ploda3=0 plodb1=16.0n plodb2=0 plodb3=0 nf_flag=1 smbt=1M smbb=1M dinsaflag=0 ppitch=0 spot=103.00n spob=103.00n spotl1=103.00n spobl1=103.00n spotl2=103.00n spobl2=103.00n spotr1=103.00n spobr1=103.00n spotr2=103.00n spobr2=103.00n
    MM0_5 (Z net58 VSS VBB) nch_svt_mac l=16.0n nfin=4 w=154.00n multi=1 nf=1 sd=74.0n sa=90n sb=90n ploda1=16.0n ploda2=0 ploda3=0 plodb1=16.0n plodb2=0 plodb3=0 nf_flag=1 smbt=1M smbb=1M dinsaflag=0 ppitch=0 spot=103.00n spob=103.00n spotl1=103.00n spobl1=103.00n spotl2=103.00n spobl2=103.00n spotr1=103.00n spobr1=103.00n spotr2=103.00n spobr2=103.00n
    MM0_8 (Z net58 VSS VBB) nch_svt_mac l=16.0n nfin=4 w=154.00n multi=1 nf=1 sd=74.0n sa=90n sb=90n ploda1=16.0n ploda2=0 ploda3=0 plodb1=16.0n plodb2=0 plodb3=0 nf_flag=1 smbt=1M smbb=1M dinsaflag=0 ppitch=0 spot=103.00n spob=103.00n spotl1=103.00n spobl1=103.00n spotl2=103.00n spobl2=103.00n spotr1=103.00n spobr1=103.00n spotr2=103.00n spobr2=103.00n
    MM19_4 (net58 I VSS VBB) nch_svt_mac l=16.0n nfin=4 w=154.00n multi=1 nf=1 sd=74.0n sa=90n sb=90n ploda1=16.0n ploda2=0 ploda3=0 plodb1=16.0n plodb2=0 plodb3=0 nf_flag=1 smbt=1M smbb=1M dinsaflag=0 ppitch=0 spot=103.00n spob=103.00n spotl1=103.00n spobl1=103.00n spotl2=103.00n spobl2=103.00n spotr1=103.00n spobr1=103.00n spotr2=103.00n spobr2=103.00n
    MM0_3 (Z net58 VSS VBB) nch_svt_mac l=16.0n nfin=4 w=154.00n multi=1 nf=1 sd=74.0n sa=90n sb=90n ploda1=16.0n ploda2=0 ploda3=0 plodb1=16.0n plodb2=0 plodb3=0 nf_flag=1 smbt=1M smbb=1M dinsaflag=0 ppitch=0 spot=103.00n spob=103.00n spotl1=103.00n spobl1=103.00n spotl2=103.00n spobl2=103.00n spotr1=103.00n spobr1=103.00n spotr2=103.00n spobr2=103.00n
    MM0_1 (Z net58 VSS VBB) nch_svt_mac l=16.0n nfin=4 w=154.00n multi=1 nf=1 sd=74.0n sa=90n sb=90n ploda1=16.0n ploda2=0 ploda3=0 plodb1=16.0n plodb2=0 plodb3=0 nf_flag=1 smbt=1M smbb=1M dinsaflag=0 ppitch=0 spot=103.00n spob=103.00n spotl1=103.00n spobl1=103.00n spotl2=103.00n spobl2=103.00n spotr1=103.00n spobr1=103.00n spotr2=103.00n spobr2=103.00n
    MM0_9 (Z net58 VSS VBB) nch_svt_mac l=16.0n nfin=4 w=154.00n multi=1 nf=1 sd=74.0n sa=90n sb=90n ploda1=16.0n ploda2=0 ploda3=0 plodb1=16.0n plodb2=0 plodb3=0 nf_flag=1 smbt=1M smbb=1M dinsaflag=0 ppitch=0 spot=103.00n spob=103.00n spotl1=103.00n spobl1=103.00n spotl2=103.00n spobl2=103.00n spotr1=103.00n spobr1=103.00n spotr2=103.00n spobr2=103.00n
    MM0_13 (Z net58 VSS VBB) nch_svt_mac l=16.0n nfin=4 w=154.00n multi=1 nf=1 sd=74.0n sa=90n sb=90n ploda1=16.0n ploda2=0 ploda3=0 plodb1=16.0n plodb2=0 plodb3=0 nf_flag=1 smbt=1M smbb=1M dinsaflag=0 ppitch=0 spot=103.00n spob=103.00n spotl1=103.00n spobl1=103.00n spotl2=103.00n spobl2=103.00n spotr1=103.00n spobr1=103.00n spotr2=103.00n spobr2=103.00n
    MM19_5 (net58 I VSS VBB) nch_svt_mac l=16.0n nfin=4 w=154.00n multi=1 nf=1 sd=74.0n sa=90n sb=90n ploda1=16.0n ploda2=0 ploda3=0 plodb1=16.0n plodb2=0 plodb3=0 nf_flag=1 smbt=1M smbb=1M dinsaflag=0 ppitch=0 spot=103.00n spob=103.00n spotl1=103.00n spobl1=103.00n spotl2=103.00n spobl2=103.00n spotr1=103.00n spobr1=103.00n spotr2=103.00n spobr2=103.00n
    MM0_6 (Z net58 VSS VBB) nch_svt_mac l=16.0n nfin=4 w=154.00n multi=1 nf=1 sd=74.0n sa=90n sb=90n ploda1=16.0n ploda2=0 ploda3=0 plodb1=16.0n plodb2=0 plodb3=0 nf_flag=1 smbt=1M smbb=1M dinsaflag=0 ppitch=0 spot=103.00n spob=103.00n spotl1=103.00n spobl1=103.00n spotl2=103.00n spobl2=103.00n spotr1=103.00n spobr1=103.00n spotr2=103.00n spobr2=103.00n
    MM19_3 (net58 I VSS VBB) nch_svt_mac l=16.0n nfin=4 w=154.00n multi=1 nf=1 sd=74.0n sa=90n sb=90n ploda1=16.0n ploda2=0 ploda3=0 plodb1=16.0n plodb2=0 plodb3=0 nf_flag=1 smbt=1M smbb=1M dinsaflag=0 ppitch=0 spot=103.00n spob=103.00n spotl1=103.00n spobl1=103.00n spotl2=103.00n spobl2=103.00n spotr1=103.00n spobr1=103.00n spotr2=103.00n spobr2=103.00n
    MM19_2 (net58 I VSS VBB) nch_svt_mac l=16.0n nfin=4 w=154.00n multi=1 nf=1 sd=74.0n sa=90n sb=90n ploda1=16.0n ploda2=0 ploda3=0 plodb1=16.0n plodb2=0 plodb3=0 nf_flag=1 smbt=1M smbb=1M dinsaflag=0 ppitch=0 spot=103.00n spob=103.00n spotl1=103.00n spobl1=103.00n spotl2=103.00n spobl2=103.00n spotr1=103.00n spobr1=103.00n spotr2=103.00n spobr2=103.00n
    MM0_2 (Z net58 VSS VBB) nch_svt_mac l=16.0n nfin=4 w=154.00n multi=1 nf=1 sd=74.0n sa=90n sb=90n ploda1=16.0n ploda2=0 ploda3=0 plodb1=16.0n plodb2=0 plodb3=0 nf_flag=1 smbt=1M smbb=1M dinsaflag=0 ppitch=0 spot=103.00n spob=103.00n spotl1=103.00n spobl1=103.00n spotl2=103.00n spobl2=103.00n spotr1=103.00n spobr1=103.00n spotr2=103.00n spobr2=103.00n
    MM0_4 (Z net58 VSS VBB) nch_svt_mac l=16.0n nfin=4 w=154.00n multi=1 nf=1 sd=74.0n sa=90n sb=90n ploda1=16.0n ploda2=0 ploda3=0 plodb1=16.0n plodb2=0 plodb3=0 nf_flag=1 smbt=1M smbb=1M dinsaflag=0 ppitch=0 spot=103.00n spob=103.00n spotl1=103.00n spobl1=103.00n spotl2=103.00n spobl2=103.00n spotr1=103.00n spobr1=103.00n spotr2=103.00n spobr2=103.00n
    MM19_1 (net58 I VSS VBB) nch_svt_mac l=16.0n nfin=4 w=154.00n multi=1 nf=1 sd=74.0n sa=90n sb=90n ploda1=16.0n ploda2=0 ploda3=0 plodb1=16.0n plodb2=0 plodb3=0 nf_flag=1 smbt=1M smbb=1M dinsaflag=0 ppitch=0 spot=103.00n spob=103.00n spotl1=103.00n spobl1=103.00n spotl2=103.00n spobl2=103.00n spotr1=103.00n spobr1=103.00n spotr2=103.00n spobr2=103.00n
    MM0_11 (Z net58 VSS VBB) nch_svt_mac l=16.0n nfin=4 w=154.00n multi=1 nf=1 sd=74.0n sa=90n sb=90n ploda1=16.0n ploda2=0 ploda3=0 plodb1=16.0n plodb2=0 plodb3=0 nf_flag=1 smbt=1M smbb=1M dinsaflag=0 ppitch=0 spot=103.00n spob=103.00n spotl1=103.00n spobl1=103.00n spotl2=103.00n spobl2=103.00n spotr1=103.00n spobr1=103.00n spotr2=103.00n spobr2=103.00n
    MM0_12 (Z net58 VSS VBB) nch_svt_mac l=16.0n nfin=4 w=154.00n multi=1 nf=1 sd=74.0n sa=90n sb=90n ploda1=16.0n ploda2=0 ploda3=0 plodb1=16.0n plodb2=0 plodb3=0 nf_flag=1 smbt=1M smbb=1M dinsaflag=0 ppitch=0 spot=103.00n spob=103.00n spotl1=103.00n spobl1=103.00n spotl2=103.00n spobl2=103.00n spotr1=103.00n spobr1=103.00n spotr2=103.00n spobr2=103.00n
ends BUFFD14BWP16P90

// Thesis_Tapeout/Ring_Oscillator_3stages_pin/schematic
subckt Ring_Oscillator_3stages_pin Cap1 Cap2 OUT Pre_Buffer VDD VSS u_signal
    M3 (Cap1 Pre_Buffer VSS_G VSS) nmos_rf_ulvt_nw multi=1 cbflag=2 dinsaflag=0 lr=240.0n nfin=6 ngcon=2 nr=4 ppitch=0 rcmflag=1 sa=531.00n sb=531.00n sc_b=1.099u sc_l=6.328u sc_r=1.752u sc_t=1.099u sd=118.00n sobe=724.00n sobn=806.00n sobs=806.00n sobw=5.3u wr=250.0n
    M4 (Cap2 Cap1 VSS_G VSS) nmos_rf_ulvt_nw multi=1 cbflag=2 dinsaflag=0 lr=240.0n nfin=6 ngcon=2 nr=4 ppitch=0 rcmflag=1 sa=531.00n sb=531.00n sc_b=1.099u sc_l=1.752u sc_r=1.752u sc_t=1.099u sd=118.00n sobe=724.00n sobn=806.00n sobs=806.00n sobw=724.00n wr=250.0n
    M6 (Pre_Buffer Cap2 VSS_G VSS) nmos_rf_ulvt_nw multi=1 cbflag=2 dinsaflag=0 lr=240.0n nfin=6 ngcon=2 nr=4 ppitch=0 rcmflag=1 sa=531.00n sb=531.00n sc_b=1.099u sc_l=1.752u sc_r=1.752u sc_t=1.099u sd=118.00n sobe=724.00n sobn=806.00n sobs=806.00n sobw=724.00n wr=250.0n
    I14 (u_signal net2 VDD VDD VSS VSS) invter_digital
    M1 (VSS_G u_signal VSS VSS) nch_ulvt_mac l=16.0n nfin=5 w=202.00n multi=1 nf=10 sd=74.0n sa=90n sb=90n ploda1=16.0n ploda2=0 ploda3=0 plodb1=16.0n plodb2=0 plodb3=0 nf_flag=1 smbt=1M smbb=1M dinsaflag=0 ppitch=0 spot=61.0n spob=61.0n spotl1=61.0n spobl1=61.0n spotl2=61.0n spobl2=61.0n spotr1=61.0n spobr1=61.0n spotr2=61.0n spobr2=61.0n
    M0 (VDD_G net2 VDD VDD) pch_ulvt_mac l=16.0n nfin=5 w=202.00n multi=1 nf=10 sd=74.0n sa=90n sb=90n ploda1=16.0n ploda2=0 ploda3=0 plodb1=16.0n plodb2=0 plodb3=0 nf_flag=1 smbt=1M smbb=1M dinsaflag=0 ppitch=0 spot=61.0n spob=61.0n spotl1=61.0n spobl1=61.0n spotl2=61.0n spobl2=61.0n spotr1=61.0n spobr1=61.0n spotr2=61.0n spobr2=61.0n
    I0 (Pre_Buffer OUT VDD VSS VDD VSS) BUFFD14BWP16P90
    M7 (Pre_Buffer Cap2 VDD_G VDD) pmos_rf_ulvt_nw multi=1 cbflag=2 dinsaflag=0 lr=240.0n nfin=6 ngcon=2 nr=4 ppitch=0 rcmflag=1 sa=531.00n sb=531.00n sc_b=1.099u sc_l=1.752u sc_r=1.752u sc_t=1.099u sd=118.00n sobe=724.00n sobn=806.00n sobs=806.00n sobw=724.00n wr=250.0n
    M5 (Cap2 Cap1 VDD_G VDD) pmos_rf_ulvt_nw multi=1 cbflag=2 dinsaflag=0 lr=240.0n nfin=6 ngcon=2 nr=4 ppitch=0 rcmflag=1 sa=531.00n sb=531.00n sc_b=1.099u sc_l=1.752u sc_r=1.752u sc_t=1.099u sd=118.00n sobe=724.00n sobn=806.00n sobs=806.00n sobw=724.00n wr=250.0n
    M2 (Cap1 Pre_Buffer VDD_G VDD) pmos_rf_ulvt_nw multi=1 cbflag=2 dinsaflag=0 lr=240.0n nfin=6 ngcon=2 nr=4 ppitch=0 rcmflag=1 sa=531.00n sb=531.00n sc_b=1.099u sc_l=6.328u sc_r=1.752u sc_t=1.099u sd=118.00n sobe=724.00n sobn=806.00n sobs=806.00n sobw=5.3u wr=250.0n
ends Ring_Oscillator_3stages_pin

// Thesis_Tapeout/RO_tb/schematic
I0 (net3 net2 Out Pre_buffer net7 0 net5) Ring_Oscillator_3stages_pin
V1 (net5 0) vsource dc=800.0m type=dc
V0 (net7 0) vsource dc=800.0m type=dc
C2 (Pre_buffer 0) capacitor c=5f
C1 (net3 net2) capacitor c=100f
C0 (Out 0) capacitor c=300f
simulatorOptions options temp=27
tran tran stop=10n errpreset=liberal
save Out
