// Point Netlist Generated on: Jan 20 11:01:11 2026
// Generated for: spectre
// Design Netlist Generated on: Jan 20 11:01:10 2026
// Design library name: Thesis_Tapeout
// Design cell name: MUX_C_Load
// Design view name: schematic
simulator lang=spectre
include "ade_e.scs"
global 0
parameters temperature=27
include "/eda/cadence/FFC_UNIV/pdk/TN16CRSP012W1_1_1_1P1A/iPDK_GEN2_CRN16FFCLL_v1.1_1p1a_20190628_all/iPDK_CRN16FFCLL_v1.1_1p1a_20190628_all/iPDK_CRN16FFCLL_v1.1_1p1a_20190628/tsmcN16/../models/toplevel.scs" section=top_tt

// Library name: Thesis_Tapeout
// Cell name: 2_1_MUX
// View name: calibre_rcc
subckt Thesis_Tapeout_2_1_MUX_calibre_rcc A B S VDD VSS Z
    cc_1043 (B_619 Z_792) capacitor c=4.61099e-17
    cc_1042 (B_619 Z_547) capacitor c=6.84082e-18
    cc_1041 (B_619 Z_228) capacitor c=8.89331e-18
    cc_1040 (B_619 S\'_312) capacitor c=5.46944e-18
    cc_1039 (B_619 S\'_300) capacitor c=6.15921e-18
    cc_1038 (B_619 S\'_268) capacitor c=1.56448e-17
    cc_1037 (B_597 Z_770) capacitor c=4.77696e-17
    cc_1036 (B_597 Z_575) capacitor c=6.9984e-18
    cc_1035 (B_597 Z_227) capacitor c=9.02464e-18
    cc_1034 (B_597 S_51) capacitor c=3.43636e-19
    cc_1033 (B_597 S\'_350) capacitor c=2.30549e-19
    cc_1032 (B_597 S\'_336) capacitor c=2.43853e-19
    cc_1031 (B_597 S\'_312) capacitor c=1.84408e-18
    cc_1030 (B_597 S\'_300) capacitor c=2.34738e-18
    cc_1029 (B_556 Z_792) capacitor c=5.33552e-18
    cc_1028 (B_556 Z_549) capacitor c=7.19012e-18
    cc_1027 (B_556 Z_547) capacitor c=3.83335e-17
    cc_1026 (B_556 Z_228) capacitor c=5.67922e-19
    cc_1025 (B_556 S\'_312) capacitor c=5.50928e-18
    cc_1024 (B_556 S\'_300) capacitor c=2.12571e-19
    cc_1023 (B_556 S\'_268) capacitor c=2.795e-17
    cc_1022 (B_543 Z_770) capacitor c=5.23975e-18
    cc_1021 (B_543 Z_575) capacitor c=3.89217e-17
    cc_1020 (B_543 Z_500) capacitor c=7.78902e-18
    cc_1019 (B_543 Z_387) capacitor c=4.45568e-19
    cc_1018 (B_543 Z_227) capacitor c=5.57729e-19
    cc_1017 (B_543 S_176) capacitor c=2.36401e-19
    cc_1016 (B_543 S_51) capacitor c=6.92743e-19
    cc_1015 (B_543 S\'_312) capacitor c=3.31311e-18
    cc_1014 (B_543 S\'_300) capacitor c=3.83777e-19
    cc_1013 (B_532 Z_792) capacitor c=5.11234e-18
    cc_1012 (B_532 Z_770) capacitor c=5.07826e-18
    cc_1011 (B_532 Z_575) capacitor c=3.93088e-17
    cc_1010 (B_532 Z_549) capacitor c=6.90797e-18
    cc_1009 (B_532 Z_547) capacitor c=3.93801e-17
    cc_1008 (B_532 Z_500) capacitor c=7.18226e-18
    cc_1007 (B_532 Z_228) capacitor c=5.44167e-19
    cc_1006 (B_532 Z_227) capacitor c=5.40539e-19
    cc_1005 (B_532 S\'_312) capacitor c=4.80567e-18
    cc_1004 (B_528 Z_549) capacitor c=3.38603e-17
    cc_1003 (B_528 Z_547) capacitor c=6.72526e-18
    cc_1002 (B_528 Z_500) capacitor c=8.21418e-19
    cc_1001 (B_528 Z_462) capacitor c=3.12764e-19
    cc_1000 (B_528 Z_387) capacitor c=1.18068e-18
    cc_999 (B_528 S\'_268) capacitor c=1.20841e-17
    cc_998 (B_528 S\') capacitor c=5.94283e-19
    cc_997 (B_515 Z_575) capacitor c=5.98599e-18
    cc_996 (B_515 Z_549) capacitor c=8.86453e-19
    cc_995 (B_515 Z_500) capacitor c=3.47693e-17
    cc_994 (B_515 Z_464) capacitor c=2.90133e-19
    cc_993 (B_515 Z_462) capacitor c=6.20857e-19
    cc_992 (B_515 Z_387) capacitor c=2.7651e-18
    cc_991 (B_515 Z_385) capacitor c=2.2402e-19
    cc_990 (B_515 S_234) capacitor c=4.52552e-19
    cc_989 (B_515 S_176) capacitor c=3.68645e-19
    cc_988 (B_515 S_51) capacitor c=8.60837e-19
    cc_987 (B_515 S\'_312) capacitor c=4.07653e-19
    cc_986 (B_500 Z_575) capacitor c=6.28037e-18
    cc_985 (B_500 Z_549) capacitor c=3.2688e-17
    cc_984 (B_500 Z_547) capacitor c=6.28579e-18
    cc_983 (B_500 Z_500) capacitor c=3.25294e-17
    cc_982 (B_500 Z_462) capacitor c=3.29005e-19
    cc_981 (B_500 Z_387) capacitor c=4.43815e-19
    cc_980 (B_500 Z_385) capacitor c=1.98538e-19
    cc_979 (B_500 S\'_312) capacitor c=3.94741e-19
    cc_978 (B_475 S\'_312) capacitor c=5.53547e-18
    cc_977 (B_475 S\'_268) capacitor c=2.0292e-18
    cc_976 (B_469 S\'_354) capacitor c=4.18046e-19
    cc_975 (B_469 S\'_350) capacitor c=1.32023e-18
    cc_974 (B_469 S\'_312) capacitor c=6.23543e-18
    cc_973 (B_469 S\'_268) capacitor c=3.52652e-19
    cc_972 (B_469 XM2_g) capacitor c=2.06443e-20
    cc_971 (B_463 S\'_312) capacitor c=6.00957e-18
    cc_970 (B_455 Z_387) capacitor c=5.53168e-19
    cc_969 (B_455 S_234) capacitor c=3.2178e-19
    cc_968 (B_455 S\'_268) capacitor c=3.14793e-19
    cc_967 (B_423 Z_748) capacitor c=4.62351e-17
    cc_966 (B_423 Z_537) capacitor c=6.87595e-18
    cc_965 (B_423 Z_224) capacitor c=9.07021e-18
    cc_964 (B_423 S_176) capacitor c=3.60927e-18
    cc_963 (B_423 S_165) capacitor c=1.08982e-17
    cc_962 (B_423 S_162) capacitor c=3.18326e-18
    cc_961 (B_423 S) capacitor c=8.1625e-18
    cc_960 (B_401 Z_748) capacitor c=4.26317e-17
    cc_959 (B_401 Z_674) capacitor c=7.96097e-18
    cc_958 (B_401 Z_537) capacitor c=8.24049e-18
    cc_957 (B_401 Z_224) capacitor c=8.28619e-18
    cc_956 (B_401 Z_223) capacitor c=3.817e-18
    cc_955 (B_401 Z) capacitor c=4.81031e-17
    cc_954 (B_401 S_176) capacitor c=2.77809e-18
    cc_953 (B_401 S_162) capacitor c=3.0416e-18
    cc_952 (B_401 S_150) capacitor c=5.96361e-19
    cc_951 (B_401 XM1_g) capacitor c=4.18874e-19
    cc_950 (B_377 Z_549) capacitor c=9.00161e-19
    cc_949 (B_377 Z_547) capacitor c=2.12663e-19
    cc_948 (B_377 Z_537) capacitor c=3.91472e-19
    cc_947 (B_377 Z_500) capacitor c=4.36257e-19
    cc_946 (B_377 Z_492) capacitor c=4.77925e-19
    cc_945 (B_377 Z_189) capacitor c=8.94964e-19
    cc_944 (B_377 S_234) capacitor c=2.72169e-19
    cc_943 (B_377 S_176) capacitor c=5.32906e-19
    cc_942 (B_377 S_165) capacitor c=2.23929e-18
    cc_941 (B_377 S_51) capacitor c=7.83887e-19
    cc_940 (B_377 S) capacitor c=1.65177e-18
    cc_939 (B_377 S\'_312) capacitor c=1.6833e-18
    cc_938 (B_377 S\'_300) capacitor c=1.4375e-19
    cc_937 (B_377 S\'_268) capacitor c=1.20774e-17
    cc_936 (B_377 S\') capacitor c=4.52249e-18
    cc_935 (B_377 VSS_1186) capacitor c=7.94419e-18
    cc_934 (B_377 VSS_1126) capacitor c=3.19028e-18
    cc_933 (B_377 VSS_1106) capacitor c=3.79645e-19
    cc_932 (B_377 VSS_1074) capacitor c=1.14305e-19
    cc_931 (B_377 VSS_965) capacitor c=2.01637e-19
    cc_930 (B_377 VSS) capacitor c=2.62537e-19
    cc_929 (B_377 X2_noxref_b) capacitor c=9.41923e-19
    cc_928 (B_338 Z_748) capacitor c=2.41443e-18
    cc_927 (B_338 Z_674) capacitor c=1.8425e-17
    cc_926 (B_338 Z_537) capacitor c=1.86188e-17
    cc_925 (B_338 Z_492) capacitor c=3.39071e-18
    cc_924 (B_338 Z_224) capacitor c=2.58491e-19
    cc_923 (B_338 Z_189) capacitor c=3.20797e-18
    cc_922 (B_338 Z) capacitor c=2.62766e-18
    cc_921 (B_338 S_162) capacitor c=2.22595e-18
    cc_920 (B_327 Z_537) capacitor c=7.07213e-18
    cc_919 (B_327 Z_492) capacitor c=8.19791e-19
    cc_918 (B_327 Z_462) capacitor c=1.18575e-18
    cc_917 (B_327 Z_387) capacitor c=2.59545e-19
    cc_916 (B_327 Z_385) capacitor c=4.86113e-19
    cc_915 (B_327 Z_189) capacitor c=3.42931e-17
    cc_914 (B_327 S_165) capacitor c=6.68081e-18
    cc_913 (B_327 S) capacitor c=4.58066e-18
    cc_912 (B_327 VSS_1186) capacitor c=2.55259e-19
    cc_911 (B_323 Z_549) capacitor c=1.2196e-18
    cc_910 (B_323 Z_547) capacitor c=4.70014e-19
    cc_909 (B_323 Z_537) capacitor c=8.65207e-19
    cc_908 (B_323 Z_500) capacitor c=4.2679e-19
    cc_907 (B_323 Z_492) capacitor c=1.30062e-18
    cc_906 (B_323 Z_189) capacitor c=2.2692e-18
    cc_905 (B_323 S_176) capacitor c=3.4427e-19
    cc_904 (B_323 S_165) capacitor c=8.62874e-18
    cc_903 (B_323 S_51) capacitor c=9.54464e-19
    cc_902 (B_323 S) capacitor c=5.17432e-18
    cc_901 (B_323 S\'_312) capacitor c=2.75269e-19
    cc_900 (B_323 S\'_300) capacitor c=3.17708e-19
    cc_899 (B_323 S\'_268) capacitor c=1.81692e-17
    cc_898 (B_323 S\') capacitor c=9.69907e-18
    cc_897 (B_323 VSS_1186) capacitor c=3.29612e-17
    cc_896 (B_323 VSS_1126) capacitor c=7.05095e-18
    cc_895 (B_323 VSS_1106) capacitor c=2.26231e-18
    cc_894 (B_323 VSS_1074) capacitor c=2.52631e-19
    cc_893 (B_323 VSS_965) capacitor c=4.45645e-19
    cc_892 (B_323 VSS) capacitor c=5.80243e-19
    cc_891 (B_323 X2_noxref_b) capacitor c=2.72225e-18
    cc_890 (B_319 Z_674) capacitor c=6.15958e-18
    cc_889 (B_319 Z_537) capacitor c=6.24319e-18
    cc_888 (B_319 Z_492) capacitor c=3.27729e-17
    cc_887 (B_319 Z_462) capacitor c=3.78043e-19
    cc_886 (B_319 Z_387) capacitor c=2.64809e-19
    cc_885 (B_319 Z_385) capacitor c=4.06532e-19
    cc_884 (B_319 Z_189) capacitor c=3.33151e-17
    cc_883 (B_319 S_162) capacitor c=4.3454e-19
    cc_882 (B_319 VSS_1074) capacitor c=6.85997e-19
    cc_881 (B_313 S_165) capacitor c=4.64423e-19
    cc_880 (B_313 S) capacitor c=3.18429e-19
    cc_879 (B_299 Z_462) capacitor c=1.5335e-19
    cc_878 (B_299 Z_385) capacitor c=4.98532e-19
    cc_877 (B_299 S_165) capacitor c=1.92413e-19
    cc_876 (B_299 S) capacitor c=1.31927e-19
    cc_875 (B_299 VSS_1186) capacitor c=4.81843e-18
    cc_874 (B_299 VSS_1106) capacitor c=9.13066e-19
    cc_873 (B_299 VSS_1074) capacitor c=8.93192e-19
    cc_872 (B_297 Z_674) capacitor c=5.81166e-18
    cc_871 (B_297 Z_492) capacitor c=3.45685e-17
    cc_870 (B_297 Z_462) capacitor c=1.28414e-18
    cc_869 (B_297 Z_387) capacitor c=2.73638e-19
    cc_868 (B_297 Z_385) capacitor c=1.79945e-18
    cc_867 (B_297 Z_189) capacitor c=9.70134e-19
    cc_866 (B_297 S_176) capacitor c=1.68271e-18
    cc_865 (B_297 S_162) capacitor c=2.64587e-19
    cc_864 (B_297 S_51) capacitor c=2.23477e-19
    cc_863 (B_297 S\'_268) capacitor c=9.42644e-20
    cc_862 (B_297 S\'_206) capacitor c=1.33e-19
    cc_861 (B_297 S\'_164) capacitor c=8.59703e-20
    cc_860 (B_297 S\') capacitor c=5.26752e-19
    cc_859 (B_297 VSS_1186) capacitor c=6.13434e-19
    cc_858 (B_297 VSS_1106) capacitor c=2.48083e-18
    cc_857 (B_295 Z_748) capacitor c=5.30623e-18
    cc_856 (B_295 Z_537) capacitor c=3.83265e-17
    cc_855 (B_295 Z_224) capacitor c=5.68088e-19
    cc_854 (B_295 Z_189) capacitor c=7.63171e-18
    cc_853 (B_295 S_165) capacitor c=1.9872e-17
    cc_852 (B_295 S_162) capacitor c=9.21858e-18
    cc_851 (B_295 S) capacitor c=1.22226e-17
    cc_850 (B_289 Z_748) capacitor c=2.69148e-18
    cc_849 (B_289 Z_674) capacitor c=2.05392e-17
    cc_848 (B_289 Z_537) capacitor c=2.07552e-17
    cc_847 (B_289 Z_492) capacitor c=3.77978e-18
    cc_846 (B_289 Z_224) capacitor c=2.88151e-19
    cc_845 (B_289 Z_189) capacitor c=3.57607e-18
    cc_844 (B_289 Z) capacitor c=2.92917e-18
    cc_843 (B_289 S_162) capacitor c=8.59583e-18
    cc_842 (B_281 Z_674) capacitor c=3.92037e-17
    cc_841 (B_281 Z_492) capacitor c=7.81344e-18
    cc_840 (B_281 Z_462) capacitor c=1.37801e-19
    cc_839 (B_281 Z_385) capacitor c=4.47985e-19
    cc_838 (B_281 Z) capacitor c=6.51283e-18
    cc_837 (B_281 S_176) capacitor c=2.28963e-18
    cc_836 (B_281 S_165) capacitor c=1.0496e-18
    cc_835 (B_281 S_162) capacitor c=1.0974e-17
    cc_834 (B_281 XM1_g) capacitor c=8.05386e-21
    cc_833 (B_281 S) capacitor c=1.29949e-19
    cc_832 (B_281 VSS_1186) capacitor c=6.0299e-18
    cc_831 (B_281 VSS_1106) capacitor c=1.66061e-18
    cc_830 (B_281 X2_noxref_b) capacitor c=9.68598e-19
    cc_829 (B_237 Z_674) capacitor c=7.06286e-18
    cc_828 (B_237 Z_223) capacitor c=4.4417e-18
    cc_827 (B_237 Z) capacitor c=5.27188e-17
    cc_826 (B_237 S_176) capacitor c=5.59981e-18
    cc_825 (B_237 S_162) capacitor c=2.22102e-18
    cc_824 (B_237 S_150) capacitor c=2.69163e-19
    cc_823 (B_237 VSS_1106) capacitor c=4.95436e-19
    cc_822 (B_166 Z_792) capacitor c=3.15266e-18
    cc_821 (B_166 Z_228) capacitor c=2.95422e-17
    cc_820 (B_166 S\'_354) capacitor c=4.85408e-18
    cc_819 (B_166 S\'_350) capacitor c=2.13586e-18
    cc_818 (B_166 S\'_340) capacitor c=4.8813e-18
    cc_817 (B_166 S\'_336) capacitor c=2.1361e-18
    cc_816 (B_166 S\'_312) capacitor c=4.17988e-18
    cc_815 (B_166 S\'_300) capacitor c=4.56642e-18
    cc_814 (B_166 S\'_268) capacitor c=3.13938e-18
    cc_813 (B_166 XM2_g) capacitor c=1.13531e-16
    cc_812 (B_166 XM2_g) capacitor c=3.20372e-19
    cc_811 (B_165 Z_792) capacitor c=3.20836e-18
    cc_810 (B_165 Z_770) capacitor c=3.1866e-18
    cc_809 (B_165 Z_228) capacitor c=2.97725e-17
    cc_808 (B_165 Z_227) capacitor c=3.07597e-17
    cc_807 (B_165 S\'_354) capacitor c=2.96615e-18
    cc_806 (B_165 S\'_350) capacitor c=6.55082e-18
    cc_805 (B_165 S\'_340) capacitor c=2.96968e-18
    cc_804 (B_165 S\'_336) capacitor c=6.16938e-18
    cc_803 (B_165 S\'_312) capacitor c=6.03918e-19
    cc_802 (B_165 S\'_300) capacitor c=6.23016e-19
    cc_801 (B_165 XM2_g) capacitor c=1.12545e-16
    cc_800 (B_165 XM2_g) capacitor c=1.12219e-16
    cc_799 (B_165 XM2_g) capacitor c=4.76501e-19
    cc_798 (B_164 Z_770) capacitor c=3.17236e-18
    cc_797 (B_164 Z_227) capacitor c=2.97268e-17
    cc_796 (B_164 S\'_350) capacitor c=7.06564e-18
    cc_795 (B_164 S\'_336) capacitor c=7.10129e-18
    cc_794 (B_164 S\'_312) capacitor c=1.03457e-18
    cc_793 (B_164 S\'_300) capacitor c=1.44797e-18
    cc_792 (B_164 XM2_g) capacitor c=1.13832e-16
    cc_791 (B_163 Z_748) capacitor c=3.2009e-18
    cc_790 (B_163 Z_224) capacitor c=3.33178e-17
    cc_789 (B_163 S_176) capacitor c=2.38277e-18
    cc_788 (B_163 S_165) capacitor c=3.92146e-18
    cc_787 (B_163 S_162) capacitor c=9.74494e-18
    cc_786 (B_163 S_150) capacitor c=7.35136e-18
    cc_785 (B_163 XM1_g) capacitor c=1.19226e-16
    cc_784 (B_163 XM1_g) capacitor c=4.92024e-19
    cc_783 (B_163 S) capacitor c=3.39012e-18
    cc_782 (B_163 VSS_1186) capacitor c=2.62968e-19
    cc_781 (B_162 Z_748) capacitor c=3.33856e-18
    cc_780 (B_162 Z_224) capacitor c=3.0382e-17
    cc_779 (B_162 Z_223) capacitor c=3.08089e-17
    cc_778 (B_162 Z) capacitor c=3.68304e-18
    cc_777 (B_162 S_176) capacitor c=5.54975e-19
    cc_776 (B_162 S_162) capacitor c=1.01505e-17
    cc_775 (B_162 S_150) capacitor c=9.46225e-18
    cc_774 (B_162 XM1_g) capacitor c=1.08545e-16
    cc_773 (B_162 XM1_g) capacitor c=1.08226e-16
    cc_772 (B_162 XM1_g) capacitor c=6.37214e-19
    cc_771 (B_161 Z_223) capacitor c=3.29389e-17
    cc_770 (B_161 Z) capacitor c=3.55424e-18
    cc_769 (B_161 S_176) capacitor c=5.38237e-18
    cc_768 (B_161 S_162) capacitor c=8.71677e-18
    cc_767 (B_161 S_150) capacitor c=7.42574e-18
    cc_766 (B_161 XM1_g) capacitor c=1.19742e-16
    cc_765 (B_161 VSS_1106) capacitor c=6.51463e-19
    cc_764 (B_150 S\'_268) capacitor c=6.08613e-19
    cc_763 (B_146 Z_454) capacitor c=4.35936e-19
    cc_762 (B Z_792) capacitor c=4.27046e-17
    cc_761 (B Z_770) capacitor c=4.35685e-17
    cc_760 (B Z_575) capacitor c=7.95409e-18
    cc_759 (B Z_547) capacitor c=7.96221e-18
    cc_758 (B Z_228) capacitor c=8.09659e-18
    cc_757 (B Z_227) capacitor c=8.29876e-18
    cc_756 (B S\'_336) capacitor c=7.33809e-19
    cc_755 (B S\'_312) capacitor c=2.9934e-18
    cc_754 (B S\'_300) capacitor c=2.81202e-18
    cc_753 (B XM2_g) capacitor c=2.33418e-19
    cc_752 (B XM2_g) capacitor c=2.09759e-19
    cc_751 (XM2_s S\'_354) capacitor c=7.68076e-18
    cc_750 (XM2_s S\'_350) capacitor c=1.03658e-18
    cc_749 (XM2_s S\'_340) capacitor c=8.26206e-18
    cc_748 (XM2_s S\'_336) capacitor c=1.0363e-18
    cc_747 (XM2_s S\'_312) capacitor c=3.88442e-18
    cc_746 (XM2_s S\'_300) capacitor c=3.9716e-18
    cc_745 (XM2_s S\'_268) capacitor c=3.55499e-18
    cc_744 (XM2_s XM2_g) capacitor c=2.05277e-16
    cc_743 (XM2_s XM2_g) capacitor c=5.15267e-19
    cc_742 (XM2_s S\'_354) capacitor c=4.86731e-18
    cc_741 (XM2_s S\'_350) capacitor c=4.86701e-18
    cc_740 (XM2_s S\'_340) capacitor c=4.87294e-18
    cc_739 (XM2_s S\'_336) capacitor c=4.87271e-18
    cc_738 (XM2_s XM2_g) capacitor c=2.05188e-16
    cc_737 (XM2_s XM2_g) capacitor c=2.05467e-16
    cc_736 (XM2_s XM2_g) capacitor c=7.58566e-19
    cc_735 (XM2_s S\'_350) capacitor c=9.4348e-18
    cc_734 (XM2_s S\'_336) capacitor c=8.95811e-18
    cc_733 (XM2_s S\'_312) capacitor c=6.43531e-19
    cc_732 (XM2_s S\'_300) capacitor c=7.2322e-19
    cc_731 (XM2_s XM2_g) capacitor c=2.05798e-16
    cc_730 (XM1_s S_176) capacitor c=1.30696e-18
    cc_729 (XM1_s S_165) capacitor c=4.35286e-18
    cc_728 (XM1_s S_162) capacitor c=9.48663e-18
    cc_727 (XM1_s S_150) capacitor c=8.30944e-18
    cc_726 (XM1_s XM1_g) capacitor c=1.91317e-16
    cc_725 (XM1_s XM1_g) capacitor c=7.05603e-19
    cc_724 (XM1_s S) capacitor c=3.78706e-18
    cc_723 (XM1_s VSS_1186) capacitor c=4.44887e-19
    cc_722 (XM1_s S_162) capacitor c=8.69639e-18
    cc_721 (XM1_s S_150) capacitor c=8.6964e-18
    cc_720 (XM1_s XM1_g) capacitor c=1.89786e-16
    cc_719 (XM1_s XM1_g) capacitor c=1.90772e-16
    cc_718 (XM1_s XM1_g) capacitor c=9.24804e-19
    cc_717 (XM1_s S_176) capacitor c=4.01341e-18
    cc_716 (XM1_s S_162) capacitor c=9.01057e-18
    cc_715 (XM1_s S_150) capacitor c=8.62428e-18
    cc_714 (XM1_s XM1_g) capacitor c=1.91406e-16
    cc_713 (XM1_s VSS_1106) capacitor c=7.60067e-19
    ciB_51 (B_619 VSS) capacitor c=4.1198e-18
    ciB_50 (B_597 VSS) capacitor c=7.9142e-18
    ciB_49 (B_569 VSS) capacitor c=1.90942e-19
    ciB_48 (B_567 VSS) capacitor c=2.53245e-19
    ciB_47 (B_559 VSS) capacitor c=1.36873e-18
    ciB_46 (B_556 VSS) capacitor c=2.22637e-18
    ciB_45 (B_554 VSS) capacitor c=1.05069e-18
    ciB_44 (B_546 VSS) capacitor c=2.62935e-18
    ciB_43 (B_543 VSS) capacitor c=8.68108e-18
    ciB_42 (B_541 VSS) capacitor c=3.03318e-19
    ciB_41 (B_532 VSS) capacitor c=6.36884e-19
    ciB_40 (B_528 VSS) capacitor c=1.39503e-18
    ciB_39 (B_515 VSS) capacitor c=4.17251e-18
    ciB_38 (B_500 VSS) capacitor c=9.28726e-19
    ciB_37 (B_496 VSS) capacitor c=1.01458e-19
    ciB_36 (B_475 VSS) capacitor c=1.19249e-18
    ciB_35 (B_469 VSS) capacitor c=6.49341e-18
    ciB_34 (B_463 VSS) capacitor c=1.57707e-17
    ciB_33 (B_455 VSS) capacitor c=5.71579e-18
    ciB_32 (B_445 VSS) capacitor c=2.75454e-18
    ciB_31 (B_423 VSS) capacitor c=4.00995e-18
    ciB_30 (B_401 VSS) capacitor c=8.40192e-19
    ciB_29 (B_387 VSS) capacitor c=6.38062e-19
    ciB_28 (B_377 VSS) capacitor c=9.60733e-17
    ciB_27 (B_367 VSS) capacitor c=4.24775e-19
    ciB_26 (B_351 VSS) capacitor c=2.55144e-18
    ciB_25 (B_338 VSS) capacitor c=9.32937e-19
    ciB_24 (B_327 VSS) capacitor c=1.81821e-18
    ciB_23 (B_323 VSS) capacitor c=1.40607e-16
    ciB_22 (B_319 VSS) capacitor c=2.19162e-18
    ciB_21 (B_313 VSS) capacitor c=5.76892e-19
    ciB_20 (B_305 VSS) capacitor c=9.65444e-19
    ciB_19 (B_299 VSS) capacitor c=4.53844e-18
    ciB_18 (B_297 VSS) capacitor c=3.17833e-18
    ciB_17 (B_295 VSS) capacitor c=2.05974e-18
    ciB_16 (B_289 VSS) capacitor c=4.7149e-18
    ciB_15 (B_281 VSS) capacitor c=1.55651e-17
    ciB_14 (B_271 VSS) capacitor c=8.90736e-19
    ciB_13 (B_255 VSS) capacitor c=6.84669e-18
    ciB_12 (B_237 VSS) capacitor c=7.02755e-18
    ciB_11 (B_166 VSS) capacitor c=4.69201e-17
    ciB_10 (B_165 VSS) capacitor c=5.05043e-18
    ciB_9 (B_164 VSS) capacitor c=5.22006e-17
    ciB_8 (B_163 VSS) capacitor c=4.94235e-17
    ciB_7 (B_162 VSS) capacitor c=5.54936e-18
    ciB_6 (B_161 VSS) capacitor c=5.06473e-17
    ciB_5 (B_150 VSS) capacitor c=1.29351e-18
    ciB_4 (B_146 VSS) capacitor c=1.86899e-18
    ciB_3 (B_144 VSS) capacitor c=4.05502e-18
    ciB_2 (B VSS) capacitor c=1.35823e-18
    ciB_1 (XM2_s VSS) capacitor c=2.939e-17
    ciB_0 (XM1_s VSS) capacitor c=3.57893e-17
    cc_712 (Z_792 S\'_350) capacitor c=1.89662e-19
    cc_711 (Z_792 S\'_336) capacitor c=1.85393e-19
    cc_710 (Z_792 S\'_312) capacitor c=2.34055e-18
    cc_709 (Z_792 S\'_300) capacitor c=2.05225e-18
    cc_708 (Z_792 XM2_g) capacitor c=1.91069e-19
    cc_707 (Z_792 XM2_g) capacitor c=1.82516e-19
    cc_706 (Z_770 S\'_350) capacitor c=1.91084e-19
    cc_705 (Z_770 S\'_336) capacitor c=1.86827e-19
    cc_704 (Z_770 S\'_312) capacitor c=2.41214e-18
    cc_703 (Z_770 S\'_300) capacitor c=2.17735e-18
    cc_702 (Z_770 XM2_g) capacitor c=1.83001e-19
    cc_701 (Z_770 XM2_g) capacitor c=1.91093e-19
    cc_700 (Z_748 S_176) capacitor c=2.24085e-18
    cc_699 (Z_748 S_162) capacitor c=2.22266e-18
    cc_698 (Z_674 S_176) capacitor c=5.19908e-18
    cc_697 (Z_605 A_617) capacitor c=4.47359e-17
    cc_696 (Z_605 A_554) capacitor c=5.34796e-18
    cc_695 (Z_605 A_541) capacitor c=5.15633e-18
    cc_694 (Z_605 A_166) capacitor c=2.96176e-18
    cc_693 (Z_605 A_165) capacitor c=3.07392e-18
    cc_692 (Z_605 A) capacitor c=4.14863e-17
    cc_691 (Z_605 S_295) capacitor c=9.98166e-19
    cc_690 (Z_605 S_280) capacitor c=4.02015e-19
    cc_689 (Z_605 S_264) capacitor c=2.06866e-18
    cc_688 (Z_605 S_248) capacitor c=1.97401e-18
    cc_687 (Z_583 A_571) capacitor c=4.3184e-17
    cc_686 (Z_583 A_541) capacitor c=5.07395e-18
    cc_685 (Z_583 A_528) capacitor c=6.10753e-18
    cc_684 (Z_583 A_165) capacitor c=3.08007e-18
    cc_683 (Z_583 A_164) capacitor c=3.19216e-18
    cc_682 (Z_583 A) capacitor c=4.50286e-17
    cc_681 (Z_583 S_264) capacitor c=2.00919e-18
    cc_680 (Z_583 S_248) capacitor c=2.08744e-18
    cc_679 (Z_583 XM3_g) capacitor c=4.94185e-19
    cc_678 (Z_583 XM3_g) capacitor c=8.9125e-19
    cc_677 (Z_575 S\'_336) capacitor c=4.57252e-19
    cc_676 (Z_575 S\'_300) capacitor c=6.97796e-18
    cc_675 (Z_549 A_146) capacitor c=3.59518e-19
    cc_674 (Z_549 S\'_300) capacitor c=5.21968e-19
    cc_673 (Z_549 S\'_268) capacitor c=3.41101e-18
    cc_672 (Z_549 S\') capacitor c=1.01347e-18
    cc_671 (Z_547 S_176) capacitor c=7.61354e-19
    cc_670 (Z_547 S_51) capacitor c=7.10668e-19
    cc_669 (Z_547 S\'_336) capacitor c=7.68437e-19
    cc_668 (Z_547 S\'_300) capacitor c=1.61346e-17
    cc_667 (Z_547 S\'_268) capacitor c=6.01214e-18
    cc_666 (Z_547 S\') capacitor c=3.13601e-18
    cc_665 (Z_537 S_176) capacitor c=1.30639e-17
    cc_664 (Z_537 S_165) capacitor c=1.61804e-18
    cc_663 (Z_537 S_150) capacitor c=2.79625e-19
    cc_662 (Z_537 S) capacitor c=1.91753e-18
    cc_661 (Z_537 S\'_268) capacitor c=2.20374e-18
    cc_660 (Z_537 S\') capacitor c=1.13516e-17
    cc_659 (Z_537 VSS_1126) capacitor c=6.32894e-19
    cc_658 (Z_506 S\'_268) capacitor c=9.97697e-19
    cc_657 (Z_506 S\') capacitor c=7.67922e-19
    cc_656 (Z_500 S_176) capacitor c=6.78537e-19
    cc_655 (Z_500 S_51) capacitor c=6.33365e-19
    cc_654 (Z_500 S\'_300) capacitor c=3.83818e-19
    cc_653 (Z_500 S\'_268) capacitor c=2.10373e-18
    cc_652 (Z_500 S\') capacitor c=1.61923e-18
    cc_651 (Z_492 S_176) capacitor c=2.84018e-18
    cc_650 (Z_492 S_165) capacitor c=1.52711e-19
    cc_649 (Z_492 S_51) capacitor c=5.05903e-19
    cc_648 (Z_492 S) capacitor c=1.04705e-19
    cc_647 (Z_492 S\'_268) capacitor c=1.33864e-18
    cc_646 (Z_492 S\') capacitor c=5.39851e-18
    cc_645 (Z_492 VSS_1126) capacitor c=9.51931e-19
    cc_644 (Z_489 A_571) capacitor c=7.02227e-18
    cc_643 (Z_489 A_541) capacitor c=3.95686e-17
    cc_642 (Z_489 A_528) capacitor c=3.94532e-17
    cc_641 (Z_489 A_513) capacitor c=6.10773e-18
    cc_640 (Z_489 A_487) capacitor c=7.0821e-18
    cc_639 (Z_489 A) capacitor c=7.96977e-18
    cc_638 (Z_489 S_280) capacitor c=6.36015e-19
    cc_637 (Z_489 S_248) capacitor c=7.75309e-18
    cc_636 (Z_477 A_554) capacitor c=7.69175e-18
    cc_635 (Z_477 A_541) capacitor c=6.96187e-18
    cc_634 (Z_477 A_526) capacitor c=3.33156e-17
    cc_633 (Z_477 A_513) capacitor c=3.22383e-17
    cc_632 (Z_477 A_487) capacitor c=1.32905e-18
    cc_631 (Z_477 A_365) capacitor c=7.26804e-19
    cc_630 (Z_477 A_320) capacitor c=6.23326e-19
    cc_629 (Z_477 S_248) capacitor c=4.26948e-19
    cc_628 (Z_477 S_234) capacitor c=2.31021e-18
    cc_627 (Z_477 S_51) capacitor c=1.51776e-18
    cc_626 (Z_475 A_617) capacitor c=7.38631e-18
    cc_625 (Z_475 A_554) capacitor c=3.90959e-17
    cc_624 (Z_475 A_541) capacitor c=3.96069e-17
    cc_623 (Z_475 A_526) capacitor c=6.65539e-18
    cc_622 (Z_475 A_513) capacitor c=6.12048e-18
    cc_621 (Z_475 A_365) capacitor c=2.34452e-19
    cc_620 (Z_475 A_320) capacitor c=6.06036e-19
    cc_619 (Z_475 A) capacitor c=7.96982e-18
    cc_618 (Z_475 S_280) capacitor c=6.02951e-19
    cc_617 (Z_475 S_248) capacitor c=1.8551e-17
    cc_616 (Z_475 S_234) capacitor c=1.34992e-18
    cc_615 (Z_475 S_51) capacitor c=4.04031e-18
    cc_614 (Z_464 S_176) capacitor c=2.3141e-19
    cc_613 (Z_464 S_51) capacitor c=2.16004e-19
    cc_612 (Z_464 S\'_268) capacitor c=2.45021e-18
    cc_611 (Z_464 S\') capacitor c=1.88591e-18
    cc_610 (Z_462 A_526) capacitor c=1.67762e-19
    cc_609 (Z_462 A_513) capacitor c=5.09688e-20
    cc_608 (Z_462 A_326) capacitor c=5.51177e-19
    cc_607 (Z_462 A_325) capacitor c=1.69741e-19
    cc_606 (Z_462 A_299) capacitor c=1.29895e-19
    cc_605 (Z_462 A_297) capacitor c=2.77865e-19
    cc_604 (Z_462 S_256) capacitor c=2.11899e-19
    cc_603 (Z_462 S_234) capacitor c=4.93639e-19
    cc_602 (Z_462 S_176) capacitor c=6.67471e-18
    cc_601 (Z_462 S_165) capacitor c=1.20123e-18
    cc_600 (Z_462 S_51) capacitor c=5.5912e-18
    cc_599 (Z_462 S) capacitor c=8.23614e-19
    cc_598 (Z_462 XI0_MM2_g) capacitor c=2.59423e-21
    cc_597 (Z_462 XI0_MM1_g) capacitor c=6.8807e-21
    cc_596 (Z_462 S\'_268) capacitor c=1.75629e-17
    cc_595 (Z_462 S\'_206) capacitor c=1.1549e-18
    cc_594 (Z_462 S\'_182) capacitor c=8.32137e-20
    cc_593 (Z_462 S\'_164) capacitor c=7.46517e-19
    cc_592 (Z_462 S\') capacitor c=2.38068e-17
    cc_591 (Z_462 VSS_1186) capacitor c=3.30256e-18
    cc_590 (Z_462 VSS_1126) capacitor c=4.95781e-18
    cc_589 (Z_462 VSS_1106) capacitor c=2.00544e-18
    cc_588 (Z_462 VSS_1092) capacitor c=5.43083e-20
    cc_587 (Z_462 VSS_1074) capacitor c=3.07162e-18
    cc_586 (Z_462 VSS_1045) capacitor c=9.52517e-19
    cc_585 (Z_462 VSS_862) capacitor c=1.90303e-19
    cc_584 (Z_462 VSS_831) capacitor c=5.34937e-19
    cc_583 (Z_462 VSS) capacitor c=1.47759e-19
    cc_582 (Z_460 S_51) capacitor c=3.62911e-19
    cc_581 (Z_454 A_541) capacitor c=7.01869e-18
    cc_580 (Z_454 A_528) capacitor c=7.58937e-18
    cc_579 (Z_454 A_526) capacitor c=1.07097e-18
    cc_578 (Z_454 A_513) capacitor c=3.25758e-17
    cc_577 (Z_454 A_487) capacitor c=3.34657e-17
    cc_576 (Z_454 A_365) capacitor c=1.7763e-18
    cc_575 (Z_454 A_320) capacitor c=3.49337e-18
    cc_574 (Z_454 S_248) capacitor c=2.07285e-18
    cc_573 (Z_454 S_51) capacitor c=1.26262e-18
    cc_572 (Z_438 A_422) capacitor c=4.47619e-17
    cc_571 (Z_438 A_400) capacitor c=4.14631e-17
    cc_570 (Z_438 A_337) capacitor c=2.43686e-18
    cc_569 (Z_438 A_295) capacitor c=5.36592e-18
    cc_568 (Z_438 A_289) capacitor c=2.71648e-18
    cc_567 (Z_438 A_163) capacitor c=2.95841e-18
    cc_566 (Z_438 A_162) capacitor c=3.21111e-18
    cc_565 (Z_438 S\'_179) capacitor c=2.37848e-18
    cc_564 (Z_438 S\'_164) capacitor c=2.29141e-18
    cc_563 (Z_398 A_422) capacitor c=3.04953e-18
    cc_562 (Z_398 A_400) capacitor c=3.32277e-18
    cc_561 (Z_398 A_337) capacitor c=7.74884e-18
    cc_560 (Z_398 A_326) capacitor c=2.76433e-18
    cc_559 (Z_398 A_325) capacitor c=2.61699e-18
    cc_558 (Z_398 A_295) capacitor c=1.61535e-17
    cc_557 (Z_398 A_289) capacitor c=8.63797e-18
    cc_556 (Z_398 S\'_206) capacitor c=4.07654e-19
    cc_555 (Z_398 S\'_179) capacitor c=2.02362e-18
    cc_554 (Z_398 S\'_164) capacitor c=2.63505e-19
    cc_553 (Z_387 A_526) capacitor c=2.187e-18
    cc_552 (Z_387 A_513) capacitor c=4.49162e-19
    cc_551 (Z_387 A_487) capacitor c=1.55963e-18
    cc_550 (Z_387 A_326) capacitor c=5.35654e-19
    cc_549 (Z_387 A_325) capacitor c=2.77437e-19
    cc_548 (Z_387 S_256) capacitor c=1.46958e-18
    cc_547 (Z_387 S_248) capacitor c=4.44768e-19
    cc_546 (Z_387 S_234) capacitor c=4.57547e-18
    cc_545 (Z_387 S_176) capacitor c=9.80297e-18
    cc_544 (Z_387 S_51) capacitor c=2.56618e-17
    cc_543 (Z_387 XI0_MM2_g) capacitor c=1.43592e-20
    cc_542 (Z_387 XI0_MM1_g) capacitor c=3.80852e-20
    cc_541 (Z_387 S\'_268) capacitor c=1.12477e-18
    cc_540 (Z_387 S\'_206) capacitor c=1.97529e-19
    cc_539 (Z_387 S\'_164) capacitor c=1.27681e-19
    cc_538 (Z_387 S\') capacitor c=2.78385e-18
    cc_537 (Z_387 VSS_1186) capacitor c=1.32371e-18
    cc_536 (Z_387 VSS_1126) capacitor c=1.50178e-18
    cc_535 (Z_387 VSS_1106) capacitor c=3.13135e-19
    cc_534 (Z_387 VSS_1074) capacitor c=2.04661e-19
    cc_533 (Z_387 VSS_1045) capacitor c=2.0645e-18
    cc_532 (Z_387 VSS) capacitor c=4.52063e-19
    cc_531 (Z_385 A_526) capacitor c=9.73333e-19
    cc_530 (Z_385 A_513) capacitor c=5.10611e-19
    cc_529 (Z_385 A_487) capacitor c=3.60831e-19
    cc_528 (Z_385 A_326) capacitor c=2.36552e-18
    cc_527 (Z_385 A_325) capacitor c=5.5182e-19
    cc_526 (Z_385 A_299) capacitor c=4.22283e-19
    cc_525 (Z_385 A_297) capacitor c=1.46452e-18
    cc_524 (Z_385 A_295) capacitor c=3.9109e-19
    cc_523 (Z_385 A_281) capacitor c=3.35748e-19
    cc_522 (Z_385 S_256) capacitor c=4.37854e-18
    cc_521 (Z_385 S_248) capacitor c=5.30923e-19
    cc_520 (Z_385 S_234) capacitor c=1.06534e-18
    cc_519 (Z_385 S_176) capacitor c=1.05248e-17
    cc_518 (Z_385 S_165) capacitor c=3.1373e-19
    cc_517 (Z_385 S_51) capacitor c=9.40441e-18
    cc_516 (Z_385 S) capacitor c=2.15107e-19
    cc_515 (Z_385 XI0_MM2_g) capacitor c=4.44854e-20
    cc_514 (Z_385 XI0_MM1_g) capacitor c=1.17989e-19
    cc_513 (Z_385 S\'_268) capacitor c=3.04331e-18
    cc_512 (Z_385 S\'_206) capacitor c=5.21792e-18
    cc_511 (Z_385 S\'_182) capacitor c=2.70524e-19
    cc_510 (Z_385 S\'_164) capacitor c=3.37283e-18
    cc_509 (Z_385 S\') capacitor c=2.79609e-17
    cc_508 (Z_385 VSS_1186) capacitor c=3.1325e-18
    cc_507 (Z_385 VSS_1126) capacitor c=1.25741e-18
    cc_506 (Z_385 VSS_1106) capacitor c=4.82614e-18
    cc_505 (Z_385 VSS_1092) capacitor c=1.76554e-19
    cc_504 (Z_385 VSS_1074) capacitor c=8.99361e-18
    cc_503 (Z_385 VSS_1045) capacitor c=9.43126e-18
    cc_502 (Z_385 VSS_862) capacitor c=6.18664e-19
    cc_501 (Z_385 VSS_831) capacitor c=1.73905e-18
    cc_500 (Z_385 VSS) capacitor c=2.07673e-18
    cc_499 (Z_370 A_365) capacitor c=1.32715e-19
    cc_498 (Z_370 A_320) capacitor c=3.43055e-19
    cc_497 (Z_370 S\'_206) capacitor c=9.26838e-19
    cc_496 (Z_370 S\'_179) capacitor c=2.35793e-19
    cc_495 (Z_370 S\'_164) capacitor c=5.99101e-19
    cc_494 (Z_370 S\') capacitor c=6.16758e-18
    cc_493 (Z_370 VSS_1045) capacitor c=2.09023e-19
    cc_492 (Z_368 A_422) capacitor c=4.30746e-18
    cc_491 (Z_368 A_400) capacitor c=4.69342e-18
    cc_490 (Z_368 A_337) capacitor c=1.09452e-17
    cc_489 (Z_368 A_326) capacitor c=3.90462e-18
    cc_488 (Z_368 A_325) capacitor c=3.6965e-18
    cc_487 (Z_368 A_295) capacitor c=2.28168e-17
    cc_486 (Z_368 A_289) capacitor c=1.22011e-17
    cc_485 (Z_368 S\'_206) capacitor c=2.31206e-18
    cc_484 (Z_368 S\'_179) capacitor c=8.39133e-18
    cc_483 (Z_368 S\'_164) capacitor c=1.4945e-18
    cc_482 (Z_360 A_365) capacitor c=1.44806e-19
    cc_481 (Z_360 A_320) capacitor c=3.74311e-19
    cc_480 (Z_360 S\'_206) capacitor c=2.59504e-18
    cc_479 (Z_360 S\'_179) capacitor c=7.2504e-18
    cc_478 (Z_360 S\'_164) capacitor c=1.67741e-18
    cc_477 (Z_360 S\') capacitor c=1.33471e-17
    cc_476 (Z_360 VSS_1045) capacitor c=6.78531e-19
    cc_475 (Z_353 A_365) capacitor c=6.0469e-19
    cc_474 (Z_353 A_337) capacitor c=2.61467e-18
    cc_473 (Z_353 A_326) capacitor c=7.37845e-19
    cc_472 (Z_353 A_325) capacitor c=2.57009e-17
    cc_471 (Z_353 A_320) capacitor c=1.82429e-18
    cc_470 (Z_353 A_297) capacitor c=2.64775e-17
    cc_469 (Z_353 A_289) capacitor c=2.91469e-18
    cc_468 (Z_353 A_281) capacitor c=6.09716e-18
    cc_467 (Z_353 S\'_179) capacitor c=4.27331e-19
    cc_466 (Z_340 A_400) capacitor c=7.98013e-18
    cc_465 (Z_340 A_365) capacitor c=1.63109e-19
    cc_464 (Z_340 A_337) capacitor c=1.94442e-17
    cc_463 (Z_340 A_326) capacitor c=1.99026e-19
    cc_462 (Z_340 A_325) capacitor c=1.32864e-17
    cc_461 (Z_340 A_320) capacitor c=4.92084e-19
    cc_460 (Z_340 A_297) capacitor c=1.40706e-17
    cc_459 (Z_340 A_289) capacitor c=2.16753e-17
    cc_458 (Z_340 A_281) capacitor c=4.10501e-17
    cc_457 (Z_340 A_237) capacitor c=7.51119e-18
    cc_456 (Z_340 S\'_179) capacitor c=4.65061e-18
    cc_455 (Z_318 A_400) capacitor c=4.51387e-17
    cc_454 (Z_318 A_337) capacitor c=2.39801e-18
    cc_453 (Z_318 A_289) capacitor c=2.67316e-18
    cc_452 (Z_318 A_281) capacitor c=6.06941e-18
    cc_451 (Z_318 A_237) capacitor c=4.39028e-17
    cc_450 (Z_318 A_162) capacitor c=3.21556e-18
    cc_449 (Z_318 A_161) capacitor c=3.18615e-18
    cc_448 (Z_318 S\'_179) capacitor c=2.03163e-18
    cc_447 (Z_318 S\'_164) capacitor c=2.21772e-18
    cc_446 (Z_318 XM0_g) capacitor c=6.39042e-19
    cc_445 (Z_228 S\'_354) capacitor c=6.3516e-18
    cc_444 (Z_228 S\'_350) capacitor c=3.11836e-18
    cc_443 (Z_228 S\'_340) capacitor c=6.36276e-18
    cc_442 (Z_228 S\'_336) capacitor c=3.22599e-18
    cc_441 (Z_228 S\'_312) capacitor c=7.55509e-19
    cc_440 (Z_228 S\'_300) capacitor c=1.22844e-18
    cc_439 (Z_228 XM2_g) capacitor c=1.12794e-16
    cc_438 (Z_228 XM2_g) capacitor c=1.13989e-16
    cc_437 (Z_228 XM2_g) capacitor c=4.8278e-19
    cc_436 (Z_227 S\'_350) capacitor c=9.6352e-18
    cc_435 (Z_227 S\'_336) capacitor c=9.36262e-18
    cc_434 (Z_227 S\'_312) capacitor c=7.41947e-19
    cc_433 (Z_227 S\'_300) capacitor c=1.18393e-18
    cc_432 (Z_227 XM2_g) capacitor c=1.13925e-16
    cc_431 (Z_227 XM2_g) capacitor c=1.1329e-16
    cc_430 (Z_226 A_617) capacitor c=8.68559e-18
    cc_429 (Z_226 A_554) capacitor c=5.69246e-19
    cc_428 (Z_226 A_541) capacitor c=5.48849e-19
    cc_427 (Z_226 A_166) capacitor c=3.27127e-17
    cc_426 (Z_226 A_165) capacitor c=3.31241e-17
    cc_425 (Z_226 A) capacitor c=7.91201e-18
    cc_424 (Z_226 S_299) capacitor c=6.31612e-18
    cc_423 (Z_226 S_295) capacitor c=3.3088e-18
    cc_422 (Z_226 S_280) capacitor c=9.54028e-18
    cc_421 (Z_226 S_264) capacitor c=1.03254e-18
    cc_420 (Z_226 S_248) capacitor c=9.7561e-19
    cc_419 (Z_226 XM3_g) capacitor c=1.12779e-16
    cc_418 (Z_226 XM3_g) capacitor c=1.12447e-16
    cc_417 (Z_226 XM3_g) capacitor c=4.80006e-19
    cc_416 (Z_225 A_571) capacitor c=8.64116e-18
    cc_415 (Z_225 A_541) capacitor c=5.4008e-19
    cc_414 (Z_225 A_528) capacitor c=6.50097e-19
    cc_413 (Z_225 A_165) capacitor c=3.0727e-17
    cc_412 (Z_225 A_164) capacitor c=2.95429e-17
    cc_411 (Z_225 A) capacitor c=8.48166e-18
    cc_410 (Z_225 S_295) capacitor c=9.72632e-18
    cc_409 (Z_225 S_280) capacitor c=9.32919e-18
    cc_408 (Z_225 S_264) capacitor c=1.00167e-18
    cc_407 (Z_225 S_248) capacitor c=1.04159e-18
    cc_406 (Z_225 XM3_g) capacitor c=1.14e-16
    cc_405 (Z_225 XM3_g) capacitor c=1.13407e-16
    cc_404 (Z_224 S_176) capacitor c=7.86977e-19
    cc_403 (Z_224 S_162) capacitor c=1.07514e-17
    cc_402 (Z_224 S_150) capacitor c=9.55146e-18
    cc_401 (Z_224 XM1_g) capacitor c=1.08684e-16
    cc_400 (Z_224 XM1_g) capacitor c=1.09892e-16
    cc_399 (Z_224 XM1_g) capacitor c=6.66152e-19
    cc_398 (Z_223 S_176) capacitor c=5.91995e-19
    cc_397 (Z_223 S_162) capacitor c=1.04607e-17
    cc_396 (Z_223 S_150) capacitor c=9.52353e-18
    cc_395 (Z_223 XM1_g) capacitor c=1.09875e-16
    cc_394 (Z_223 XM1_g) capacitor c=1.09357e-16
    cc_393 (Z_222 A_422) capacitor c=8.89457e-18
    cc_392 (Z_222 A_400) capacitor c=8.06627e-18
    cc_391 (Z_222 A_337) capacitor c=2.60892e-19
    cc_390 (Z_222 A_295) capacitor c=5.74479e-19
    cc_389 (Z_222 A_289) capacitor c=2.90828e-19
    cc_388 (Z_222 A_163) capacitor c=3.29516e-17
    cc_387 (Z_222 A_162) capacitor c=3.34929e-17
    cc_386 (Z_222 S\'_179) capacitor c=1.02572e-17
    cc_385 (Z_222 S\'_164) capacitor c=1.07368e-17
    cc_384 (Z_222 XM0_g) capacitor c=1.08832e-16
    cc_383 (Z_222 XM0_g) capacitor c=1.08566e-16
    cc_382 (Z_222 XM0_g) capacitor c=6.62814e-19
    cc_381 (Z_221 A_400) capacitor c=8.53459e-18
    cc_380 (Z_221 A_337) capacitor c=2.56732e-19
    cc_379 (Z_221 A_289) capacitor c=2.86191e-19
    cc_378 (Z_221 A_281) capacitor c=6.49795e-19
    cc_377 (Z_221 A_237) capacitor c=8.57326e-18
    cc_376 (Z_221 A_162) capacitor c=3.08843e-17
    cc_375 (Z_221 A_161) capacitor c=3.2756e-17
    cc_374 (Z_221 S\'_179) capacitor c=1.02962e-17
    cc_373 (Z_221 S\'_164) capacitor c=1.07509e-17
    cc_372 (Z_221 XM0_g) capacitor c=1.09924e-16
    cc_371 (Z_221 XM0_g) capacitor c=1.0946e-16
    cc_370 (Z_189 S_176) capacitor c=4.47731e-19
    cc_369 (Z_189 S_165) capacitor c=1.72995e-18
    cc_368 (Z_189 S) capacitor c=1.18613e-18
    cc_367 (Z_181 A_365) capacitor c=1.69114e-19
    cc_366 (Z_181 A_337) capacitor c=3.30924e-18
    cc_365 (Z_181 A_326) capacitor c=3.31926e-17
    cc_364 (Z_181 A_325) capacitor c=3.24779e-17
    cc_363 (Z_181 A_320) capacitor c=8.99069e-19
    cc_362 (Z_181 A_297) capacitor c=1.23074e-18
    cc_361 (Z_181 A_295) capacitor c=7.24763e-18
    cc_360 (Z_181 A_289) capacitor c=3.68896e-18
    cc_359 (Z_181 S_176) capacitor c=2.69473e-19
    cc_358 (Z_181 S_51) capacitor c=2.51533e-19
    cc_357 (Z_181 S\'_206) capacitor c=2.5532e-18
    cc_356 (Z_181 S\'_179) capacitor c=4.12064e-19
    cc_355 (Z_181 S\'_164) capacitor c=1.65037e-18
    cc_354 (Z_178 A_365) capacitor c=7.11369e-20
    cc_353 (Z_178 A_320) capacitor c=1.83883e-19
    cc_352 (Z_178 S\') capacitor c=6.25209e-19
    cc_351 (Z_150 S_176) capacitor c=6.7347e-18
    cc_350 (Z_150 S_51) capacitor c=2.24093e-19
    cc_349 (Z_150 S\'_268) capacitor c=7.43247e-20
    cc_348 (Z_150 S\') capacitor c=4.15329e-19
    cc_347 (Z S_176) capacitor c=2.52365e-18
    cc_346 (Z S_162) capacitor c=2.52826e-18
    cc_345 (XM2_d S\'_354) capacitor c=1.0811e-17
    cc_344 (XM2_d S\'_340) capacitor c=9.73624e-18
    cc_343 (XM2_d XM2_g) capacitor c=2.05434e-16
    cc_342 (XM2_d XM2_g) capacitor c=2.0546e-16
    cc_341 (XM2_d XM2_g) capacitor c=8.12936e-19
    cc_340 (XM2_d S\'_350) capacitor c=9.73127e-18
    cc_339 (XM2_d S\'_336) capacitor c=9.73624e-18
    cc_338 (XM2_d XM2_g) capacitor c=2.05188e-16
    cc_337 (XM2_d XM2_g) capacitor c=2.06203e-16
    cc_336 (XM3_d S_299) capacitor c=1.06781e-17
    cc_335 (XM3_d S_280) capacitor c=9.73371e-18
    cc_334 (XM3_d XM3_g) capacitor c=2.0478e-16
    cc_333 (XM3_d XM3_g) capacitor c=2.05057e-16
    cc_332 (XM3_d XM3_g) capacitor c=8.07499e-19
    cc_331 (XM3_d S_295) capacitor c=9.74053e-18
    cc_330 (XM3_d S_280) capacitor c=9.7337e-18
    cc_329 (XM3_d XM3_g) capacitor c=2.04539e-16
    cc_328 (XM3_d XM3_g) capacitor c=2.05792e-16
    cc_327 (XM1_d S_162) capacitor c=8.66903e-18
    cc_326 (XM1_d S_150) capacitor c=8.68999e-18
    cc_325 (XM1_d XM1_g) capacitor c=1.90073e-16
    cc_324 (XM1_d XM1_g) capacitor c=1.90772e-16
    cc_323 (XM1_d XM1_g) capacitor c=9.55646e-19
    cc_322 (XM1_d S_162) capacitor c=8.79758e-18
    cc_321 (XM1_d S_150) capacitor c=8.69e-18
    cc_320 (XM1_d XM1_g) capacitor c=1.89786e-16
    cc_319 (XM1_d XM1_g) capacitor c=1.91735e-16
    cc_318 (XM0_d S\'_179) capacitor c=8.66811e-18
    cc_317 (XM0_d S\'_164) capacitor c=8.6735e-18
    cc_316 (XM0_d XM0_g) capacitor c=1.90764e-16
    cc_315 (XM0_d XM0_g) capacitor c=1.92006e-16
    cc_314 (XM0_d XM0_g) capacitor c=9.54716e-19
    cc_313 (XM0_d S\'_179) capacitor c=8.66811e-18
    cc_312 (XM0_d S\'_164) capacitor c=8.67352e-18
    cc_311 (XM0_d XM0_g) capacitor c=1.90448e-16
    cc_310 (XM0_d XM0_g) capacitor c=1.9296e-16
    ciZ_62 (Z_792 VSS) capacitor c=1.25946e-18
    ciZ_61 (Z_770 VSS) capacitor c=9.84558e-19
    ciZ_60 (Z_748 VSS) capacitor c=1.15245e-18
    ciZ_59 (Z_720 VSS) capacitor c=2.69302e-19
    ciZ_58 (Z_706 VSS) capacitor c=9.6501e-19
    ciZ_57 (Z_695 VSS) capacitor c=9.83277e-19
    ciZ_56 (Z_692 VSS) capacitor c=5.72867e-19
    ciZ_55 (Z_684 VSS) capacitor c=4.06449e-19
    ciZ_54 (Z_674 VSS) capacitor c=8.98253e-19
    ciZ_53 (Z_660 VSS) capacitor c=1.14174e-19
    ciZ_52 (Z_645 VSS) capacitor c=8.38986e-19
    ciZ_51 (Z_642 VSS) capacitor c=3.50707e-19
    ciZ_50 (Z_630 VSS) capacitor c=6.37902e-19
    ciZ_49 (Z_626 VSS) capacitor c=1.43095e-19
    ciZ_48 (Z_605 VSS) capacitor c=1.12209e-18
    ciZ_47 (Z_583 VSS) capacitor c=9.6264e-19
    ciZ_46 (Z_575 VSS) capacitor c=7.20129e-18
    ciZ_45 (Z_563 VSS) capacitor c=8.3328e-19
    ciZ_44 (Z_551 VSS) capacitor c=7.75966e-19
    ciZ_43 (Z_549 VSS) capacitor c=1.55941e-18
    ciZ_42 (Z_547 VSS) capacitor c=1.11807e-17
    ciZ_41 (Z_537 VSS) capacitor c=6.30458e-18
    ciZ_40 (Z_522 VSS) capacitor c=2.97624e-19
    ciZ_39 (Z_509 VSS) capacitor c=7.16167e-19
    ciZ_38 (Z_506 VSS) capacitor c=4.65539e-18
    ciZ_37 (Z_500 VSS) capacitor c=9.16664e-18
    ciZ_36 (Z_498 VSS) capacitor c=4.06209e-18
    ciZ_35 (Z_492 VSS) capacitor c=7.41264e-18
    ciZ_34 (Z_489 VSS) capacitor c=6.43575e-18
    ciZ_33 (Z_477 VSS) capacitor c=2.11927e-18
    ciZ_32 (Z_475 VSS) capacitor c=1.18822e-17
    ciZ_31 (Z_464 VSS) capacitor c=2.42604e-17
    ciZ_30 (Z_462 VSS) capacitor c=1.13658e-16
    ciZ_29 (Z_460 VSS) capacitor c=5.28644e-18
    ciZ_28 (Z_454 VSS) capacitor c=1.09768e-17
    ciZ_27 (Z_438 VSS) capacitor c=1.16074e-18
    ciZ_26 (Z_430 VSS) capacitor c=3.00263e-19
    ciZ_25 (Z_398 VSS) capacitor c=5.71694e-19
    ciZ_24 (Z_390 VSS) capacitor c=4.09372e-19
    ciZ_23 (Z_387 VSS) capacitor c=5.97836e-17
    ciZ_22 (Z_385 VSS) capacitor c=1.54465e-16
    ciZ_21 (Z_376 VSS) capacitor c=4.23827e-18
    ciZ_20 (Z_370 VSS) capacitor c=5.83887e-18
    ciZ_19 (Z_368 VSS) capacitor c=3.66786e-18
    ciZ_18 (Z_360 VSS) capacitor c=7.41946e-18
    ciZ_17 (Z_357 VSS) capacitor c=1.63808e-20
    ciZ_16 (Z_353 VSS) capacitor c=1.20616e-18
    ciZ_15 (Z_346 VSS) capacitor c=1.7246e-19
    ciZ_14 (Z_340 VSS) capacitor c=1.91384e-18
    ciZ_13 (Z_318 VSS) capacitor c=2.24764e-18
    ciZ_12 (Z_228 VSS) capacitor c=5.21353e-18
    ciZ_11 (Z_227 VSS) capacitor c=5.11387e-18
    ciZ_10 (Z_226 VSS) capacitor c=4.81932e-18
    ciZ_9 (Z_225 VSS) capacitor c=4.86847e-18
    ciZ_8 (Z_224 VSS) capacitor c=5.41116e-18
    ciZ_7 (Z_223 VSS) capacitor c=4.62901e-18
    ciZ_6 (Z_222 VSS) capacitor c=5.42301e-18
    ciZ_5 (Z_221 VSS) capacitor c=4.89041e-18
    ciZ_4 (Z_189 VSS) capacitor c=1.89713e-18
    ciZ_3 (Z_181 VSS) capacitor c=1.51717e-18
    ciZ_2 (Z_178 VSS) capacitor c=1.17393e-18
    ciZ_1 (Z_150 VSS) capacitor c=4.03497e-18
    ciZ_0 (Z VSS) capacitor c=1.77261e-18
    cc_309 (S_299 A_468) capacitor c=4.17521e-19
    cc_308 (S_299 A_166) capacitor c=4.8286e-18
    cc_307 (S_299 A_165) capacitor c=2.96628e-18
    cc_306 (S_299 XM3_s) capacitor c=7.67124e-18
    cc_305 (S_299 XM3_s) capacitor c=4.87089e-18
    cc_304 (S_295 A_571) capacitor c=4.25487e-19
    cc_303 (S_295 A_468) capacitor c=1.29978e-18
    cc_302 (S_295 A_166) capacitor c=2.10133e-18
    cc_301 (S_295 A_165) capacitor c=6.35666e-18
    cc_300 (S_295 A_164) capacitor c=7.04763e-18
    cc_299 (S_295 A) capacitor c=4.19207e-19
    cc_298 (S_295 XM3_s) capacitor c=1.03135e-18
    cc_297 (S_295 XM3_s) capacitor c=4.87268e-18
    cc_296 (S_295 XM3_s) capacitor c=9.40463e-18
    cc_295 (S_280 A_166) capacitor c=6.95805e-18
    cc_294 (S_280 A_165) capacitor c=9.32869e-18
    cc_293 (S_280 A_164) capacitor c=7.07109e-18
    cc_292 (S_280 A) capacitor c=4.47713e-19
    cc_291 (S_280 XM3_s) capacitor c=9.27833e-18
    cc_290 (S_280 XM3_s) capacitor c=9.74311e-18
    cc_289 (S_280 XM3_s) capacitor c=8.86924e-18
    cc_288 (S_264 A_617) capacitor c=5.56296e-18
    cc_287 (S_264 A_571) capacitor c=1.85538e-18
    cc_286 (S_264 A_554) capacitor c=5.69688e-18
    cc_285 (S_264 A_541) capacitor c=4.79e-18
    cc_284 (S_264 A_528) capacitor c=3.31286e-18
    cc_283 (S_264 A_513) capacitor c=5.40769e-19
    cc_282 (S_264 A_487) capacitor c=2.66919e-19
    cc_281 (S_264 A_481) capacitor c=3.35058e-18
    cc_280 (S_264 A_474) capacitor c=5.49736e-18
    cc_279 (S_264 A_468) capacitor c=9.42842e-18
    cc_278 (S_264 A_440) capacitor c=3.24224e-19
    cc_277 (S_264 A_166) capacitor c=4.27262e-18
    cc_276 (S_264 A_165) capacitor c=6.19272e-19
    cc_275 (S_264 A_164) capacitor c=1.24583e-18
    cc_274 (S_264 A) capacitor c=2.46103e-18
    cc_273 (S_264 XM3_s) capacitor c=3.80751e-18
    cc_272 (S_264 XM3_s) capacitor c=6.3873e-19
    cc_271 (S_256 A_487) capacitor c=2.91779e-19
    cc_270 (S_256 A_365) capacitor c=7.51276e-18
    cc_269 (S_256 A_320) capacitor c=1.6293e-17
    cc_268 (S_256 noxref_14_4) capacitor c=1.39966e-17
    cc_267 (S_256 noxref_14) capacitor c=3.19555e-19
    cc_266 (S_256 noxref_13_4) capacitor c=1.41645e-17
    cc_265 (S_256 noxref_13) capacitor c=3.45983e-19
    cc_264 (S_256 noxref_8_4) capacitor c=1.14538e-17
    cc_263 (S_256 noxref_8) capacitor c=2.94334e-19
    cc_262 (S_256 noxref_7_4) capacitor c=1.14818e-17
    cc_261 (S_256 noxref_7) capacitor c=3.06864e-19
    cc_260 (S_256 XI0_MM2_d) capacitor c=1.0011e-17
    cc_259 (S_256 XI0_MM1_d) capacitor c=6.25526e-18
    cc_258 (S_256 S\') capacitor c=4.8389e-17
    cc_257 (S_256 VSS_1045) capacitor c=1.12167e-17
    cc_256 (S_256 X2_noxref_s) capacitor c=9.96477e-18
    cc_255 (S_248 A_617) capacitor c=6.15687e-18
    cc_254 (S_248 A_571) capacitor c=5.46873e-18
    cc_253 (S_248 A_528) capacitor c=1.80628e-18
    cc_252 (S_248 A_487) capacitor c=8.96191e-19
    cc_251 (S_248 A_365) capacitor c=2.24293e-18
    cc_250 (S_248 A_320) capacitor c=4.09421e-18
    cc_249 (S_248 A_166) capacitor c=4.59639e-18
    cc_248 (S_248 A_165) capacitor c=4.50848e-19
    cc_247 (S_248 A_164) capacitor c=4.62648e-18
    cc_246 (S_248 A) capacitor c=2.79609e-18
    cc_245 (S_248 XM3_s) capacitor c=3.79631e-18
    cc_244 (S_248 XM3_s) capacitor c=4.02815e-18
    cc_243 (S_234 A_617) capacitor c=1.50809e-17
    cc_242 (S_234 A_554) capacitor c=2.79535e-17
    cc_241 (S_234 A_526) capacitor c=1.20103e-17
    cc_240 (S_234 A_513) capacitor c=4.8404e-19
    cc_239 (S_234 A_474) capacitor c=2.08121e-18
    cc_238 (S_234 A_468) capacitor c=6.67217e-19
    cc_237 (S_234 A_440) capacitor c=9.06487e-19
    cc_236 (S_234 A_365) capacitor c=5.69673e-19
    cc_235 (S_234 A_166) capacitor c=2.70067e-18
    cc_234 (S_234 A_150) capacitor c=8.63074e-19
    cc_233 (S_234 XM3_s) capacitor c=2.85467e-18
    cc_232 (S_176 A_365) capacitor c=5.42305e-19
    cc_231 (S_176 A_320) capacitor c=4.00487e-19
    cc_230 (S_176 S\'_300) capacitor c=1.78722e-19
    cc_229 (S_176 S\'_268) capacitor c=4.05213e-18
    cc_228 (S_176 S\'_206) capacitor c=1.23988e-19
    cc_227 (S_176 S\'_164) capacitor c=8.01449e-20
    cc_226 (S_176 S\') capacitor c=2.22386e-17
    cc_225 (S_176 VSS_1126) capacitor c=8.01773e-18
    cc_224 (S_176 VSS_1106) capacitor c=1.08212e-17
    cc_223 (S_176 VSS_1074) capacitor c=1.3244e-18
    cc_222 (S_176 VSS_1045) capacitor c=1.05175e-18
    cc_221 (S_176 VSS_862) capacitor c=1.20426e-18
    cc_220 (S_176 X2_noxref_b) capacitor c=3.28503e-18
    cc_219 (S_165 S\'_268) capacitor c=3.09048e-19
    cc_218 (S_165 S\') capacitor c=6.59975e-19
    cc_217 (S_165 VSS_1186) capacitor c=2.54138e-18
    cc_216 (S_165 VSS_1126) capacitor c=3.11414e-19
    cc_215 (S_162 VSS_1186) capacitor c=8.60399e-19
    cc_214 (S_150 S\'_268) capacitor c=3.27831e-20
    cc_213 (S_150 S\') capacitor c=1.83193e-19
    cc_212 (S_120 noxref_14_3) capacitor c=1.42742e-18
    cc_211 (S_120 noxref_13_3) capacitor c=1.25641e-18
    cc_210 (S_120 XI0_MM2_d) capacitor c=6.86413e-18
    cc_209 (S_120 S\') capacitor c=2.30177e-18
    cc_208 (XM3_g A_166) capacitor c=1.12034e-16
    cc_207 (XM3_g XM3_s) capacitor c=2.04868e-16
    cc_206 (XM3_g A_165) capacitor c=1.12584e-16
    cc_205 (XM3_g A) capacitor c=2.3283e-19
    cc_204 (XM3_g XM3_s) capacitor c=2.0454e-16
    cc_203 (XM3_g A_165) capacitor c=1.12247e-16
    cc_202 (XM3_g A) capacitor c=2.09609e-19
    cc_201 (XM3_g XM3_s) capacitor c=2.05025e-16
    cc_200 (XM3_g A_468) capacitor c=2.06639e-20
    cc_199 (XM3_g A_166) capacitor c=3.18246e-19
    cc_198 (XM3_g A_165) capacitor c=4.71384e-19
    cc_197 (XM3_g A_164) capacitor c=1.14203e-16
    cc_196 (XM3_g XM3_s) capacitor c=5.1512e-19
    cc_195 (XM3_g XM3_s) capacitor c=7.58835e-19
    cc_194 (XM3_g XM3_s) capacitor c=2.05139e-16
    cc_193 (S_51 A_526) capacitor c=9.76504e-19
    cc_192 (S_51 A_365) capacitor c=7.96543e-19
    cc_191 (S_51 A_320) capacitor c=1.12433e-18
    cc_190 (S_51 A_166) capacitor c=2.59496e-19
    cc_189 (S_51 XM3_s) capacitor c=3.7144e-19
    cc_188 (S_51 S\'_300) capacitor c=1.66824e-19
    cc_187 (S_51 S\'_268) capacitor c=3.04067e-18
    cc_186 (S_51 S\'_206) capacitor c=1.15734e-19
    cc_185 (S_51 S\'_164) capacitor c=7.48094e-20
    cc_184 (S_51 S\') capacitor c=1.66135e-17
    cc_183 (S_51 VSS_1126) capacitor c=6.75347e-18
    cc_182 (S_51 VSS_1106) capacitor c=2.87382e-18
    cc_181 (S_51 VSS_1074) capacitor c=3.69356e-19
    cc_180 (S_51 VSS_1045) capacitor c=1.74634e-18
    cc_179 (S_51 X2_noxref_b) capacitor c=3.93944e-19
    cc_178 (S S\'_268) capacitor c=4.31051e-19
    cc_177 (S S\') capacitor c=1.09691e-18
    cc_176 (S VSS_1186) capacitor c=2.13104e-18
    cc_175 (S VSS_1126) capacitor c=1.54407e-18
    cc_174 (XI0_MM2_g A_487) capacitor c=2.85096e-21
    cc_173 (XI0_MM2_g A_365) capacitor c=7.6337e-20
    cc_172 (XI0_MM2_g A_320) capacitor c=1.66772e-19
    cc_171 (XI0_MM2_g noxref_14_4) capacitor c=9.96942e-19
    cc_170 (XI0_MM2_g noxref_14) capacitor c=5.79005e-20
    cc_169 (XI0_MM2_g noxref_13_4) capacitor c=1.04843e-18
    cc_168 (XI0_MM2_g noxref_13) capacitor c=6.92136e-20
    cc_167 (XI0_MM2_g noxref_8_4) capacitor c=3.23803e-19
    cc_166 (XI0_MM2_g noxref_8) capacitor c=8.32093e-21
    cc_165 (XI0_MM2_g noxref_7_4) capacitor c=3.24596e-19
    cc_164 (XI0_MM2_g noxref_7) capacitor c=8.67514e-21
    cc_163 (XI0_MM2_g XI0_MM2_d) capacitor c=5.77945e-17
    cc_162 (XI0_MM2_g XI0_MM1_d) capacitor c=1.70116e-19
    cc_161 (XI0_MM2_g S\') capacitor c=1.62844e-17
    cc_160 (XI0_MM2_g VSS_1045) capacitor c=1.94079e-19
    cc_159 (XI0_MM2_g X2_noxref_s) capacitor c=2.38519e-19
    cc_158 (XI0_MM1_g A_487) capacitor c=7.56164e-21
    cc_157 (XI0_MM1_g A_365) capacitor c=2.02469e-19
    cc_156 (XI0_MM1_g A_320) capacitor c=4.42331e-19
    cc_155 (XI0_MM1_g noxref_14_4) capacitor c=1.04949e-18
    cc_154 (XI0_MM1_g noxref_14) capacitor c=2.39608e-20
    cc_153 (XI0_MM1_g noxref_13_4) capacitor c=1.07283e-18
    cc_152 (XI0_MM1_g noxref_13) capacitor c=2.59424e-20
    cc_151 (XI0_MM1_g noxref_8_4) capacitor c=2.73619e-18
    cc_150 (XI0_MM1_g noxref_8) capacitor c=1.63158e-18
    cc_149 (XI0_MM1_g noxref_7_4) capacitor c=2.72043e-18
    cc_148 (XI0_MM1_g noxref_7) capacitor c=1.63322e-18
    cc_147 (XI0_MM1_g XI0_MM2_d) capacitor c=6.51394e-19
    cc_146 (XI0_MM1_g XI0_MM1_d) capacitor c=5.95472e-17
    cc_145 (XI0_MM1_g S\') capacitor c=2.07194e-17
    cc_144 (XI0_MM1_g VSS_1045) capacitor c=1.1697e-17
    cc_143 (XI0_MM1_g X2_noxref_s) capacitor c=6.57908e-17
    ciS_18 (S_299 VSS) capacitor c=1.90587e-17
    ciS_17 (S_295 VSS) capacitor c=2.78052e-17
    ciS_16 (S_280 VSS) capacitor c=3.98267e-17
    ciS_15 (S_264 VSS) capacitor c=3.36442e-17
    ciS_14 (S_256 VSS) capacitor c=1.68061e-16
    ciS_13 (S_248 VSS) capacitor c=7.22005e-17
    ciS_12 (S_234 VSS) capacitor c=2.37783e-17
    ciS_11 (S_187 VSS) capacitor c=4.06293e-18
    ciS_10 (S_176 VSS) capacitor c=9.96198e-17
    ciS_9 (S_165 VSS) capacitor c=4.75587e-17
    ciS_8 (S_162 VSS) capacitor c=5.09404e-17
    ciS_7 (S_150 VSS) capacitor c=4.24695e-17
    ciS_6 (S_120 VSS) capacitor c=1.34762e-17
    ciS_5 (XM3_g VSS) capacitor c=1.63084e-16
    ciS_4 (XM1_g VSS) capacitor c=1.99342e-16
    ciS_3 (S_51 VSS) capacitor c=1.54641e-16
    ciS_2 (S VSS) capacitor c=2.82039e-17
    ciS_1 (XI0_MM2_g VSS) capacitor c=8.27513e-17
    ciS_0 (XI0_MM1_g VSS) capacitor c=2.18297e-17
    cc_142 (S\'_268 A_365) capacitor c=3.26918e-20
    cc_141 (S\'_268 A_320) capacitor c=8.45053e-20
    cc_140 (S\'_268 VSS_1186) capacitor c=1.32409e-19
    cc_139 (S\'_268 VSS_1126) capacitor c=1.8332e-17
    cc_138 (S\'_268 VSS_1106) capacitor c=4.0526e-18
    cc_137 (S\'_268 VSS_1092) capacitor c=2.59666e-19
    cc_136 (S\'_268 VSS_1074) capacitor c=1.73551e-18
    cc_135 (S\'_268 VSS_1045) capacitor c=6.05637e-18
    cc_134 (S\'_268 X2_noxref_b) capacitor c=1.39305e-18
    cc_133 (S\'_206 A_422) capacitor c=9.22192e-18
    cc_132 (S\'_206 A_365) capacitor c=7.364e-20
    cc_131 (S\'_206 A_326) capacitor c=7.32968e-18
    cc_130 (S\'_206 A_325) capacitor c=3.83661e-19
    cc_129 (S\'_206 A_320) capacitor c=5.52094e-19
    cc_128 (S\'_206 A_307) capacitor c=3.24237e-19
    cc_127 (S\'_206 A_299) capacitor c=6.99507e-19
    cc_126 (S\'_206 A_295) capacitor c=1.83656e-17
    cc_125 (S\'_206 A_281) capacitor c=3.10034e-19
    cc_124 (S\'_206 A_163) capacitor c=1.89198e-18
    cc_123 (S\'_206 XM0_s) capacitor c=1.90282e-18
    cc_122 (S\'_206 VSS_1106) capacitor c=5.48137e-19
    cc_121 (S\'_206 VSS_1074) capacitor c=2.99041e-18
    cc_120 (S\'_206 VSS_1045) capacitor c=6.22496e-19
    cc_119 (S\'_206 X2_noxref_b) capacitor c=1.6053e-19
    cc_118 (S\'_182 A_422) capacitor c=2.29254e-18
    cc_117 (S\'_182 A_163) capacitor c=2.13155e-18
    cc_116 (S\'_182 XM0_s) capacitor c=2.3765e-18
    cc_115 (S\'_182 VSS_1074) capacitor c=5.01926e-19
    cc_114 (S\'_179 A_422) capacitor c=3.8107e-18
    cc_113 (S\'_179 A_400) capacitor c=3.46178e-18
    cc_112 (S\'_179 A_297) capacitor c=2.56619e-19
    cc_111 (S\'_179 A_281) capacitor c=4.56918e-19
    cc_110 (S\'_179 A_237) capacitor c=2.84366e-18
    cc_109 (S\'_179 A_163) capacitor c=9.5891e-18
    cc_108 (S\'_179 A_162) capacitor c=9.9007e-18
    cc_107 (S\'_179 A_161) capacitor c=8.88819e-18
    cc_106 (S\'_179 XM0_s) capacitor c=9.5326e-18
    cc_105 (S\'_179 XM0_s) capacitor c=8.6745e-18
    cc_104 (S\'_179 XM0_s) capacitor c=9.3703e-18
    cc_103 (S\'_179 VSS_1045) capacitor c=5.76443e-19
    cc_102 (S\'_164 A_422) capacitor c=1.16752e-17
    cc_101 (S\'_164 A_400) capacitor c=2.71823e-18
    cc_100 (S\'_164 A_365) capacitor c=4.76004e-20
    cc_99 (S\'_164 A_337) capacitor c=2.16021e-18
    cc_98 (S\'_164 A_326) capacitor c=4.73785e-18
    cc_97 (S\'_164 A_325) capacitor c=9.78156e-19
    cc_96 (S\'_164 A_320) capacitor c=3.5687e-19
    cc_95 (S\'_164 A_307) capacitor c=2.09584e-19
    cc_94 (S\'_164 A_299) capacitor c=7.88558e-19
    cc_93 (S\'_164 A_297) capacitor c=2.99348e-19
    cc_92 (S\'_164 A_295) capacitor c=2.35213e-17
    cc_91 (S\'_164 A_289) capacitor c=8.47677e-18
    cc_90 (S\'_164 A_281) capacitor c=1.23678e-17
    cc_89 (S\'_164 A_237) capacitor c=2.07726e-18
    cc_88 (S\'_164 A_163) capacitor c=1.30955e-17
    cc_87 (S\'_164 A_162) capacitor c=9.86611e-18
    cc_86 (S\'_164 A_161) capacitor c=9.03666e-18
    cc_85 (S\'_164 XM0_s) capacitor c=1.31918e-17
    cc_84 (S\'_164 XM0_s) capacitor c=8.70087e-18
    cc_83 (S\'_164 XM0_s) capacitor c=9.14259e-18
    cc_82 (S\'_164 VSS_1106) capacitor c=5.86954e-19
    cc_81 (S\'_164 VSS_1074) capacitor c=4.38109e-18
    cc_80 (S\'_164 VSS_1045) capacitor c=4.02377e-19
    cc_79 (S\'_164 X2_noxref_b) capacitor c=1.03766e-19
    cc_78 (XI0_MM2_d A_365) capacitor c=6.94106e-20
    cc_77 (XI0_MM2_d A_320) capacitor c=1.7942e-19
    cc_76 (XI0_MM2_d noxref_14_4) capacitor c=6.08385e-18
    cc_75 (XI0_MM2_d noxref_14_3) capacitor c=6.99623e-18
    cc_74 (XI0_MM2_d noxref_14) capacitor c=5.92632e-17
    cc_73 (XI0_MM2_d VSS_1045) capacitor c=1.95543e-19
    cc_72 (XI0_MM2_d X2_noxref_s) capacitor c=7.59646e-20
    cc_71 (XI0_MM1_d A_365) capacitor c=2.3958e-20
    cc_70 (XI0_MM1_d A_320) capacitor c=6.19294e-20
    cc_69 (XI0_MM1_d noxref_8_4) capacitor c=5.4881e-18
    cc_68 (XI0_MM1_d noxref_8) capacitor c=6.01184e-17
    cc_67 (XI0_MM1_d VSS_1045) capacitor c=7.36065e-18
    cc_66 (XI0_MM1_d X2_noxref_s) capacitor c=8.12178e-18
    cc_65 (XM0_g A_163) capacitor c=1.19022e-16
    cc_64 (XM0_g XM0_s) capacitor c=1.92551e-16
    cc_63 (XM0_g A_400) capacitor c=4.18692e-19
    cc_62 (XM0_g A_162) capacitor c=1.08658e-16
    cc_61 (XM0_g XM0_s) capacitor c=1.90478e-16
    cc_60 (XM0_g A_162) capacitor c=1.08358e-16
    cc_59 (XM0_g XM0_s) capacitor c=1.92005e-16
    cc_58 (XM0_g A_281) capacitor c=8.08927e-21
    cc_57 (XM0_g A_163) capacitor c=4.89852e-19
    cc_56 (XM0_g A_162) capacitor c=6.37247e-19
    cc_55 (XM0_g A_161) capacitor c=1.19879e-16
    cc_54 (XM0_g XM0_s) capacitor c=7.0602e-19
    cc_53 (XM0_g XM0_s) capacitor c=9.23878e-19
    cc_52 (XM0_g XM0_s) capacitor c=1.91329e-16
    cc_51 (S\' A_365) capacitor c=5.21023e-18
    cc_50 (S\' A_320) capacitor c=1.3468e-17
    cc_49 (S\' A_297) capacitor c=4.94203e-19
    cc_48 (S\' A_161) capacitor c=2.69604e-19
    cc_47 (S\' XM0_s) capacitor c=3.65312e-19
    cc_46 (S\' noxref_14_4) capacitor c=4.92147e-18
    cc_45 (S\' noxref_14_3) capacitor c=2.73869e-18
    cc_44 (S\' noxref_14) capacitor c=1.83453e-17
    cc_43 (S\' noxref_8_4) capacitor c=4.82406e-18
    cc_42 (S\' noxref_8) capacitor c=2.24466e-17
    cc_41 (S\' VSS_1186) capacitor c=1.01914e-19
    cc_40 (S\' VSS_1126) capacitor c=6.495e-17
    cc_39 (S\' VSS_1106) capacitor c=2.2646e-17
    cc_38 (S\' VSS_1092) capacitor c=1.45102e-18
    cc_37 (S\' VSS_1074) capacitor c=9.69807e-18
    cc_36 (S\' VSS_1045) capacitor c=1.36798e-16
    cc_35 (S\' VSS_1019) capacitor c=1.05355e-18
    cc_34 (S\' X2_noxref_s) capacitor c=2.54853e-17
    cc_33 (S\' VSS) capacitor c=3.02549e-17
    cc_32 (S\' X2_noxref_b) capacitor c=1.07684e-17
    ciS\'_15 (S\'_354 VSS) capacitor c=1.88746e-17
    ciS\'_14 (S\'_350 VSS) capacitor c=2.79877e-17
    ciS\'_13 (S\'_340 VSS) capacitor c=1.91594e-17
    ciS\'_12 (S\'_336 VSS) capacitor c=2.77473e-17
    ciS\'_11 (S\'_312 VSS) capacitor c=3.22745e-17
    ciS\'_10 (S\'_300 VSS) capacitor c=3.07292e-17
    ciS\'_9 (S\'_268 VSS) capacitor c=5.62112e-17
    ciS\'_8 (S\'_206 VSS) capacitor c=2.47625e-17
    ciS\'_7 (S\'_182 VSS) capacitor c=3.01686e-17
    ciS\'_6 (S\'_179 VSS) capacitor c=5.16171e-17
    ciS\'_5 (S\'_164 VSS) capacitor c=1.00696e-16
    ciS\'_4 (XI0_MM2_d VSS) capacitor c=2.45478e-17
    ciS\'_3 (XI0_MM1_d VSS) capacitor c=1.43418e-17
    ciS\'_2 (XM2_g VSS) capacitor c=1.55504e-16
    ciS\'_1 (XM0_g VSS) capacitor c=1.93158e-16
    ciS\'_0 (S\' VSS) capacitor c=1.30145e-16
    cc_31 (A_365 VSS_1186) capacitor c=2.13302e-19
    cc_30 (A_365 VSS_1074) capacitor c=1.8371e-18
    cc_29 (A_365 VSS_1045) capacitor c=2.83969e-18
    cc_28 (A_365 VSS_728) capacitor c=2.03118e-19
    cc_27 (A_365 X2_noxref_s) capacitor c=1.85276e-19
    cc_26 (A_365 VSS) capacitor c=5.13005e-18
    cc_25 (A_365 X2_noxref_b) capacitor c=4.69455e-19
    cc_24 (A_326 VSS_1074) capacitor c=1.49998e-18
    cc_23 (A_325 VSS_1186) capacitor c=8.3302e-19
    cc_22 (A_320 VSS_1186) capacitor c=5.51367e-19
    cc_21 (A_320 VSS_1074) capacitor c=1.59727e-17
    cc_20 (A_320 VSS_1045) capacitor c=7.34034e-18
    cc_19 (A_320 VSS_728) capacitor c=5.25043e-19
    cc_18 (A_320 X2_noxref_s) capacitor c=4.78921e-19
    cc_17 (A_320 VSS) capacitor c=2.02418e-17
    cc_16 (A_320 X2_noxref_b) capacitor c=1.89985e-18
    cc_15 (A_299 VSS_1186) capacitor c=3.79666e-19
    cc_14 (A_299 VSS_1074) capacitor c=5.43546e-18
    cc_13 (A_297 VSS) capacitor c=1.32697e-18
    cc_12 (A_281 VSS_1074) capacitor c=5.97752e-18
    cc_11 (A_281 VSS) capacitor c=8.60111e-19
    cc_10 (A_281 X2_noxref_b) capacitor c=8.34039e-19
    cc_9 (A_237 VSS) capacitor c=7.4849e-19
    cc_8 (A_163 VSS_1074) capacitor c=2.39935e-19
    cc_7 (A_161 VSS) capacitor c=5.53261e-19
    cc_6 (XM0_s VSS_1074) capacitor c=3.42899e-19
    cc_5 (XM0_s VSS) capacitor c=6.13091e-19
    ciA_47 (A_617 VSS) capacitor c=4.01038e-18
    ciA_46 (A_571 VSS) capacitor c=6.53211e-18
    ciA_45 (A_565 VSS) capacitor c=3.06177e-19
    ciA_44 (A_557 VSS) capacitor c=1.33238e-18
    ciA_43 (A_554 VSS) capacitor c=2.85171e-18
    ciA_42 (A_552 VSS) capacitor c=1.15918e-19
    ciA_41 (A_541 VSS) capacitor c=1.1397e-18
    ciA_40 (A_539 VSS) capacitor c=9.44235e-19
    ciA_39 (A_531 VSS) capacitor c=2.17017e-18
    ciA_38 (A_528 VSS) capacitor c=6.86394e-18
    ciA_37 (A_526 VSS) capacitor c=2.43245e-18
    ciA_36 (A_513 VSS) capacitor c=6.99039e-19
    ciA_35 (A_498 VSS) capacitor c=5.09212e-19
    ciA_34 (A_487 VSS) capacitor c=3.6943e-18
    ciA_33 (A_481 VSS) capacitor c=9.11693e-18
    ciA_32 (A_474 VSS) capacitor c=1.52167e-18
    ciA_31 (A_468 VSS) capacitor c=1.16917e-17
    ciA_30 (A_440 VSS) capacitor c=8.59003e-18
    ciA_29 (A_422 VSS) capacitor c=4.57867e-18
    ciA_28 (A_400 VSS) capacitor c=8.88726e-19
    ciA_27 (A_386 VSS) capacitor c=7.47232e-19
    ciA_26 (A_373 VSS) capacitor c=3.07284e-19
    ciA_25 (A_365 VSS) capacitor c=9.91851e-17
    ciA_24 (A_350 VSS) capacitor c=3.02704e-18
    ciA_23 (A_337 VSS) capacitor c=9.75974e-19
    ciA_22 (A_326 VSS) capacitor c=2.61694e-18
    ciA_21 (A_325 VSS) capacitor c=1.78227e-18
    ciA_20 (A_320 VSS) capacitor c=1.47929e-16
    ciA_19 (A_307 VSS) capacitor c=2.22786e-19
    ciA_18 (A_299 VSS) capacitor c=3.57068e-18
    ciA_17 (A_297 VSS) capacitor c=2.89494e-18
    ciA_16 (A_295 VSS) capacitor c=2.54369e-18
    ciA_15 (A_289 VSS) capacitor c=4.64162e-18
    ciA_14 (A_281 VSS) capacitor c=1.51713e-17
    ciA_13 (A_271 VSS) capacitor c=8.79039e-19
    ciA_12 (A_255 VSS) capacitor c=7.38945e-18
    ciA_11 (A_237 VSS) capacitor c=7.90467e-18
    ciA_10 (A_166 VSS) capacitor c=4.8484e-17
    ciA_9 (A_165 VSS) capacitor c=4.59342e-18
    ciA_8 (A_164 VSS) capacitor c=4.88445e-17
    ciA_7 (A_163 VSS) capacitor c=4.9627e-17
    ciA_6 (A_162 VSS) capacitor c=5.09346e-18
    ciA_5 (A_161 VSS) capacitor c=5.19545e-17
    ciA_4 (A_150 VSS) capacitor c=2.67244e-18
    ciA_3 (A_146 VSS) capacitor c=1.19401e-18
    ciA_2 (A VSS) capacitor c=1.37746e-18
    ciA_1 (XM3_s VSS) capacitor c=2.91321e-17
    ciA_0 (XM0_s VSS) capacitor c=3.61979e-17
    cinoxref_14_2 (noxref_14_4 VSS) capacitor c=1.69899e-17
    cinoxref_14_1 (noxref_14_3 VSS) capacitor c=7.33983e-18
    cinoxref_14_0 (noxref_14 VSS) capacitor c=1.72716e-17
    cinoxref_13_2 (noxref_13_4 VSS) capacitor c=2.75105e-17
    cinoxref_13_1 (noxref_13_3 VSS) capacitor c=1.71652e-17
    cinoxref_13_0 (noxref_13 VSS) capacitor c=9.42917e-17
    cinoxref_8_1 (noxref_8_4 VSS) capacitor c=1.60057e-17
    cinoxref_8_0 (noxref_8 VSS) capacitor c=2.6246e-17
    cc_4 (noxref_7_4 VSS_1045) capacitor c=1.81881e-18
    cc_3 (noxref_7_4 X2_noxref_s) capacitor c=6.73927e-18
    cc_2 (noxref_7 VSS_1045) capacitor c=1.29807e-17
    cc_1 (noxref_7 X2_noxref_s) capacitor c=6.73737e-17
    cinoxref_7_1 (noxref_7_4 VSS) capacitor c=1.75547e-17
    cinoxref_7_0 (noxref_7 VSS) capacitor c=2.75997e-17
    ciVSS_22 (VSS_1204 VSS) capacitor c=1.47595e-17
    ciVSS_21 (VSS_1188 VSS) capacitor c=1.02125e-17
    ciVSS_20 (VSS_1186 VSS) capacitor c=1.39272e-16
    ciVSS_19 (VSS_1126 VSS) capacitor c=1.05784e-16
    ciVSS_18 (VSS_1106 VSS) capacitor c=1.27894e-16
    ciVSS_17 (VSS_1092 VSS) capacitor c=1.36839e-17
    ciVSS_16 (VSS_1076 VSS) capacitor c=9.66924e-18
    ciVSS_15 (VSS_1074 VSS) capacitor c=1.21171e-16
    ciVSS_14 (VSS_1045 VSS) capacitor c=2.30105e-16
    ciVSS_13 (VSS_1019 VSS) capacitor c=2.12486e-17
    ciVSS_12 (VSS_1015 VSS) capacitor c=2.096e-18
    ciVSS_11 (VSS_995 VSS) capacitor c=9.50887e-17
    ciVSS_10 (VSS_983 VSS) capacitor c=3.23434e-18
    ciVSS_9 (VSS_965 VSS) capacitor c=3.72294e-17
    ciVSS_8 (VSS_880 VSS) capacitor c=2.54483e-18
    ciVSS_7 (VSS_862 VSS) capacitor c=3.40751e-17
    ciVSS_6 (VSS_849 VSS) capacitor c=3.03914e-18
    ciVSS_5 (VSS_831 VSS) capacitor c=3.52491e-17
    ciVSS_4 (VSS_746 VSS) capacitor c=2.69931e-18
    ciVSS_3 (VSS_728 VSS) capacitor c=3.64934e-17
    ciVSS_2 (X2_noxref_s VSS) capacitor c=2.43066e-17
    ciVSS_1 (VSS VSS) capacitor c=6.06092e-17
    ciVSS_0 (X2_noxref_b VSS) capacitor c=4.76201e-16
    rB_276 (B_631 B_627) resistor r=3.71123
    rB_275 (B_631 B_567) resistor r=12.4893
    rB_274 (B_623 B_627) resistor r=3.43745
    rB_273 (B_623 B_563) resistor r=12.4893
    rB_272 (B_619 B_623) resistor r=4.15999
    rB_271 (B_619 B_561) resistor r=12.4893
    rB_270 (B_619 B_559) resistor r=20.3209
    rB_269 (B_609 B_605) resistor r=3.71123
    rB_268 (B_609 B_554) resistor r=12.4893
    rB_267 (B_601 B_605) resistor r=3.43745
    rB_266 (B_601 B_550) resistor r=12.4893
    rB_265 (B_597 B_601) resistor r=4.15999
    rB_264 (B_597 B_548) resistor r=12.4893
    rB_263 (B_597 B_546) resistor r=20.3209
    rB_262 (B_589 B_541) resistor r=12.4893
    rB_261 (B_585 B_589) resistor r=4.4059
    rB_260 (B_585 B_581) resistor r=3.9139
    rB_259 (B_585 B_538) resistor r=12.4893
    rB_258 (B_577 B_581) resistor r=3.62345
    rB_257 (B_577 B_534) resistor r=12.4893
    rB_256 (B_573 B_577) resistor r=4.38872
    rB_255 (B_573 B_532) resistor r=12.4893
    rB_254 (B_569 B_573) resistor r=4.37759
    rB_253 (B_569 B_532) resistor r=18.2232
    rB_252 (B_569 B_496) resistor r=114.393
    rB_251 (B_565 B_627) resistor r=12.4893
    rB_250 (B_565 B_567) resistor r=3.51803
    rB_249 (B_565 B_528) resistor r=28.1809
    rB_248 (B_563 B_565) resistor r=3.51803
    rB_247 (B_561 B_563) resistor r=3.51803
    rB_246 (B_561 B_524) resistor r=18.2403
    rB_245 (B_559 B_561) resistor r=3.3848
    rB_244 (B_559 B_524) resistor r=22.9172
    rB_243 (B_556 B_631) resistor r=20.3637
    rB_242 (B_556 B_567) resistor r=3.47792
    rB_241 (B_556 B_528) resistor r=23.485
    rB_240 (B_556 B_475) resistor r=6.7611
    rB_239 (B_552 B_605) resistor r=12.4893
    rB_238 (B_552 B_554) resistor r=3.71733
    rB_237 (B_552 B_515) resistor r=28.1809
    rB_236 (B_550 B_552) resistor r=3.71733
    rB_235 (B_548 B_550) resistor r=3.71733
    rB_234 (B_548 B_511) resistor r=18.2403
    rB_233 (B_546 B_548) resistor r=3.5689
    rB_232 (B_546 B_511) resistor r=22.9172
    rB_231 (B_543 B_609) resistor r=20.3637
    rB_230 (B_543 B_554) resistor r=3.67209
    rB_229 (B_543 B_515) resistor r=23.485
    rB_228 (B_543 B_469) resistor r=7.04053
    rB_227 (B_541 B_538) resistor r=3.82165
    rB_226 (B_541 B_500) resistor r=24.3836
    rB_225 (B_536 B_581) resistor r=12.4893
    rB_224 (B_536 B_538) resistor r=3.91249
    rB_223 (B_536 B_500) resistor r=28.3474
    rB_222 (B_534 B_536) resistor r=3.91249
    rB_221 (B_532 B_534) resistor r=3.91249
    rB_220 (B_532 B_496) resistor r=12.0223
    rB_219 (B_528 B_567) resistor r=12.4893
    rB_218 (B_524 B_565) resistor r=28.1809
    rB_217 (B_524 B_563) resistor r=12.4893
    rB_216 (B_524 B_528) resistor r=7.22562
    rB_215 (B_515 B_554) resistor r=12.4893
    rB_214 (B_511 B_552) resistor r=28.1809
    rB_213 (B_511 B_550) resistor r=12.4893
    rB_212 (B_511 B_515) resistor r=7.22562
    rB_211 (B_500 B_538) resistor r=12.4893
    rB_210 (B_496 B_536) resistor r=28.3474
    rB_209 (B_496 B_534) resistor r=12.4893
    rB_208 (B_496 B_500) resistor r=7.64642
    rB_207 (B_463 B_541) resistor r=6.27118
    rB_206 (B_463 B_475) resistor r=0.409256
    rB_205 (B_463 B_469) resistor r=0.409256
    rB_204 (B_463 B_445) resistor r=7.28926
    rB_203 (B_463 B_146) resistor r=8.35328
    rB_202 (B_455 B_475) resistor r=7.28926
    rB_201 (B_455 B_445) resistor r=0.41592
    rB_200 (B_445 B_469) resistor r=12.3798
    rB_199 (B_435 B_362) resistor r=20.3209
    rB_198 (B_435 B_360) resistor r=12.4893
    rB_197 (B_431 B_435) resistor r=4.15999
    rB_196 (B_431 B_427) resistor r=3.43745
    rB_195 (B_431 B_358) resistor r=12.4893
    rB_194 (B_423 B_427) resistor r=3.71123
    rB_193 (B_423 B_354) resistor r=12.4893
    rB_192 (B_413 B_349) resistor r=20.7487
    rB_191 (B_413 B_347) resistor r=12.4893
    rB_190 (B_409 B_413) resistor r=4.38872
    rB_189 (B_409 B_405) resistor r=3.62345
    rB_188 (B_409 B_345) resistor r=12.4893
    rB_187 (B_401 B_405) resistor r=3.9139
    rB_186 (B_401 B_341) resistor r=12.4893
    rB_185 (B_391 B_362) resistor r=22.9172
    rB_184 (B_391 B_360) resistor r=18.2403
    rB_183 (B_387 B_391) resistor r=7.22562
    rB_182 (B_387 B_356) resistor r=28.1809
    rB_181 (B_377 B_455) resistor r=5.86969
    rB_180 (B_377 B_445) resistor r=10.3561
    rB_179 (B_377 B_323) resistor r=26.2647
    rB_178 (B_371 B_349) resistor r=23.5046
    rB_177 (B_371 B_347) resistor r=18.5113
    rB_176 (B_367 B_371) resistor r=7.64642
    rB_175 (B_367 B_343) resistor r=28.3474
    rB_174 (B_360 B_362) resistor r=3.3848
    rB_173 (B_358 B_391) resistor r=12.4893
    rB_172 (B_358 B_360) resistor r=3.51803
    rB_171 (B_356 B_427) resistor r=12.4893
    rB_170 (B_356 B_391) resistor r=28.1809
    rB_169 (B_356 B_358) resistor r=3.51803
    rB_168 (B_354 B_387) resistor r=12.4893
    rB_167 (B_354 B_356) resistor r=3.51803
    rB_166 (B_351 B_423) resistor r=20.3637
    rB_165 (B_351 B_387) resistor r=23.485
    rB_164 (B_351 B_354) resistor r=3.47792
    rB_163 (B_351 B_327) resistor r=24.5288
    rB_162 (B_347 B_349) resistor r=3.74437
    rB_161 (B_345 B_371) resistor r=12.4893
    rB_160 (B_345 B_347) resistor r=3.91249
    rB_159 (B_343 B_405) resistor r=12.4893
    rB_158 (B_343 B_371) resistor r=28.3474
    rB_157 (B_343 B_345) resistor r=3.91249
    rB_156 (B_341 B_367) resistor r=12.4893
    rB_155 (B_341 B_343) resistor r=3.91249
    rB_154 (B_338 B_401) resistor r=20.794
    rB_153 (B_338 B_367) resistor r=24.3836
    rB_152 (B_338 B_341) resistor r=3.82165
    rB_151 (B_338 B_319) resistor r=26.1564
    rB_150 (B_327 B_387) resistor r=9.48638
    rB_149 (B_327 B_313) resistor r=0.685702
    rB_148 (B_319 B_367) resistor r=9.32794
    rB_147 (B_319 B_305) resistor r=0.481215
    rB_146 (B_313 B_323) resistor r=5.86969
    rB_145 (B_305 B_323) resistor r=10.3561
    rB_144 (B_305 B_313) resistor r=0.41592
    rB_143 (B_299 B_305) resistor r=0.428099
    rB_142 (B_299 B_297) resistor r=0.669294
    rB_141 (B_299 B_281) resistor r=9.87494
    rB_140 (B_297 B_281) resistor r=8.21966
    rB_139 (B_297 B_271) resistor r=9.48638
    rB_138 (B_295 B_351) resistor r=6.7611
    rB_137 (B_295 B_327) resistor r=8.89447
    rB_136 (B_295 B_313) resistor r=7.28926
    rB_135 (B_289 B_338) resistor r=6.27118
    rB_134 (B_289 B_319) resistor r=8.35328
    rB_133 (B_289 B_305) resistor r=7.28926
    rB_132 (B_289 B_299) resistor r=29.7516
    rB_131 (B_289 B_295) resistor r=0.409256
    rB_130 (B_289 B_281) resistor r=0.494965
    rB_129 (B_271 B_275) resistor r=7.22562
    rB_128 (B_266 B_275) resistor r=22.9172
    rB_127 (B_264 B_275) resistor r=18.2403
    rB_126 (B_264 B_266) resistor r=3.5689
    rB_125 (B_262 B_275) resistor r=12.4893
    rB_124 (B_262 B_264) resistor r=3.71733
    rB_123 (B_260 B_275) resistor r=28.1809
    rB_122 (B_260 B_271) resistor r=28.1809
    rB_121 (B_260 B_262) resistor r=3.71733
    rB_120 (B_258 B_271) resistor r=12.4893
    rB_119 (B_258 B_260) resistor r=3.71733
    rB_118 (B_255 B_297) resistor r=28.2866
    rB_117 (B_255 B_281) resistor r=6.53587
    rB_116 (B_255 B_271) resistor r=23.485
    rB_115 (B_255 B_258) resistor r=3.67209
    rB_114 (B_255 B_237) resistor r=20.3637
    rB_113 (B_249 B_266) resistor r=20.3209
    rB_112 (B_249 B_264) resistor r=12.4893
    rB_111 (B_245 B_262) resistor r=12.4893
    rB_110 (B_245 B_249) resistor r=4.15999
    rB_109 (B_245 B_241) resistor r=3.43745
    rB_108 (B_241 B_260) resistor r=12.4893
    rB_107 (B_237 B_258) resistor r=12.4893
    rB_106 (B_237 B_241) resistor r=3.71123
    rB_105 (B_166 B_631) resistor r=7.60619
    rB_104 (B_166 B_627) resistor r=15.4957
    rB_103 (B_166 B_623) resistor r=11.7021
    rB_102 (B_166 B_619) resistor r=7.41083
    rB_101 (B_166 B_559) resistor r=68.9237
    rB_100 (B_166 B_556) resistor r=68.7687
    rB_99 (B_165 B_589) resistor r=14.1137
    rB_98 (B_165 B_585) resistor r=11.3773
    rB_97 (B_165 B_581) resistor r=15.5228
    rB_96 (B_165 B_577) resistor r=11.7129
    rB_95 (B_165 B_573) resistor r=10.9692
    rB_94 (B_165 B_569) resistor r=14.0844
    rB_93 (B_164 B_609) resistor r=7.60619
    rB_92 (B_164 B_605) resistor r=15.4957
    rB_91 (B_164 B_601) resistor r=11.7021
    rB_90 (B_164 B_597) resistor r=7.41083
    rB_89 (B_164 B_546) resistor r=68.9237
    rB_88 (B_164 B_543) resistor r=68.7687
    rB_87 (B_163 B_435) resistor r=7.41083
    rB_86 (B_163 B_431) resistor r=11.7021
    rB_85 (B_163 B_427) resistor r=15.4957
    rB_84 (B_163 B_423) resistor r=7.60619
    rB_83 (B_163 B_362) resistor r=68.9237
    rB_82 (B_163 B_351) resistor r=68.7687
    rB_81 (B_163 XM1_s) resistor r=12.7787
    rB_80 (B_162 B_413) resistor r=7.46815
    rB_79 (B_162 B_409) resistor r=11.7129
    rB_78 (B_162 B_405) resistor r=15.5228
    rB_77 (B_162 B_401) resistor r=7.66576
    rB_76 (B_162 B_349) resistor r=66.7567
    rB_75 (B_162 B_338) resistor r=66.6106
    rB_74 (B_161 B_266) resistor r=68.9237
    rB_73 (B_161 B_255) resistor r=68.7687
    rB_72 (B_161 B_249) resistor r=7.41083
    rB_71 (B_161 B_245) resistor r=11.7021
    rB_70 (B_161 B_241) resistor r=15.4957
    rB_69 (B_161 B_237) resistor r=7.60619
    rB_68 (B_150 B_556) resistor r=24.5288
    rB_67 (B_150 B_528) resistor r=9.48638
    rB_66 (B_150 B_475) resistor r=8.89447
    rB_65 (B_150 B_455) resistor r=0.685702
    rB_64 (B_146 B_541) resistor r=26.1564
    rB_63 (B_146 B_500) resistor r=9.32794
    rB_62 (B_146 B_445) resistor r=0.481215
    rB_61 (B_144 B_543) resistor r=24.8693
    rB_60 (B_144 B_515) resistor r=9.48638
    rB_59 (B_144 B_469) resistor r=6.0751
    rB_58 (B_144 B_445) resistor r=1.1367
    rB_57 (B B_589) resistor r=0.952095
    rB_56 (XM2_s B_166) resistor r=19.6459
    rB_55 (XM2_s B_165) resistor r=19.6459
    rB_54 (XM2_s B_164) resistor r=19.6459
    rB_53 (XM1_s B_162) resistor r=12.7787
    rB_52 (XM1_s B_161) resistor r=12.7787
    rZ_323 (Z_800 Z_796) resistor r=3.74715
    rZ_322 (Z_800 Z_714) resistor r=23.0973
    rZ_321 (Z_800 Z_712) resistor r=12.4893
    rZ_320 (Z_792 Z_796) resistor r=3.79301
    rZ_319 (Z_792 Z_708) resistor r=12.4893
    rZ_318 (Z_792 Z_706) resistor r=23.0464
    rZ_317 (Z_778 Z_774) resistor r=3.74715
    rZ_316 (Z_778 Z_703) resistor r=23.0973
    rZ_315 (Z_778 Z_701) resistor r=12.4893
    rZ_314 (Z_770 Z_774) resistor r=3.79301
    rZ_313 (Z_770 Z_697) resistor r=12.4893
    rZ_312 (Z_770 Z_695) resistor r=23.0464
    rZ_311 (Z_756 Z_752) resistor r=3.79301
    rZ_310 (Z_756 Z_692) resistor r=23.0464
    rZ_309 (Z_756 Z_690) resistor r=12.4893
    rZ_308 (Z_748 Z_752) resistor r=3.74715
    rZ_307 (Z_748 Z_686) resistor r=12.4893
    rZ_306 (Z_748 Z_684) resistor r=23.0973
    rZ_305 (Z_736 Z_680) resistor r=12.4893
    rZ_304 (Z_732 Z_736) resistor r=4.3768
    rZ_303 (Z_732 Z_728) resistor r=3.79301
    rZ_302 (Z_732 Z_678) resistor r=12.4893
    rZ_301 (Z_724 Z_728) resistor r=3.74715
    rZ_300 (Z_724 Z_674) resistor r=12.4893
    rZ_299 (Z_720 Z_724) resistor r=4.40477
    rZ_298 (Z_720 Z_674) resistor r=18.2232
    rZ_297 (Z_720 Z_626) resistor r=114.393
    rZ_296 (Z_712 Z_714) resistor r=3.91249
    rZ_295 (Z_710 Z_796) resistor r=12.4893
    rZ_294 (Z_710 Z_712) resistor r=3.91249
    rZ_293 (Z_710 Z_664) resistor r=28.3474
    rZ_292 (Z_708 Z_710) resistor r=3.91249
    rZ_291 (Z_706 Z_708) resistor r=3.91249
    rZ_290 (Z_706 Z_660) resistor r=22.0573
    rZ_289 (Z_701 Z_703) resistor r=3.74437
    rZ_288 (Z_699 Z_774) resistor r=12.4893
    rZ_287 (Z_699 Z_701) resistor r=3.91249
    rZ_286 (Z_697 Z_699) resistor r=3.91249
    rZ_285 (Z_697 Z_649) resistor r=28.3474
    rZ_284 (Z_695 Z_697) resistor r=3.91249
    rZ_283 (Z_690 Z_692) resistor r=3.91249
    rZ_282 (Z_690 Z_642) resistor r=28.3474
    rZ_281 (Z_688 Z_752) resistor r=12.4893
    rZ_280 (Z_688 Z_690) resistor r=3.91249
    rZ_279 (Z_686 Z_688) resistor r=3.91249
    rZ_278 (Z_686 Z_638) resistor r=18.5113
    rZ_277 (Z_684 Z_686) resistor r=3.74437
    rZ_276 (Z_684 Z_638) resistor r=23.5046
    rZ_275 (Z_678 Z_680) resistor r=3.91249
    rZ_274 (Z_678 Z_630) resistor r=28.3474
    rZ_273 (Z_676 Z_728) resistor r=12.4893
    rZ_272 (Z_676 Z_678) resistor r=3.91249
    rZ_271 (Z_674 Z_676) resistor r=3.91249
    rZ_270 (Z_674 Z_626) resistor r=12.0223
    rZ_269 (Z_664 Z_714) resistor r=15.8581
    rZ_268 (Z_664 Z_712) resistor r=12.4893
    rZ_267 (Z_660 Z_710) resistor r=28.3474
    rZ_266 (Z_660 Z_708) resistor r=12.4893
    rZ_265 (Z_660 Z_664) resistor r=7.64642
    rZ_264 (Z_649 Z_703) resistor r=23.5046
    rZ_263 (Z_649 Z_701) resistor r=18.5113
    rZ_262 (Z_649 Z_699) resistor r=12.4893
    rZ_261 (Z_645 Z_697) resistor r=28.3474
    rZ_260 (Z_645 Z_695) resistor r=12.4893
    rZ_259 (Z_645 Z_649) resistor r=7.64642
    rZ_258 (Z_642 Z_692) resistor r=12.4893
    rZ_257 (Z_638 Z_690) resistor r=28.3474
    rZ_256 (Z_638 Z_688) resistor r=12.4893
    rZ_255 (Z_638 Z_642) resistor r=7.64642
    rZ_254 (Z_630 Z_680) resistor r=12.4893
    rZ_253 (Z_626 Z_678) resistor r=28.3474
    rZ_252 (Z_626 Z_676) resistor r=12.4893
    rZ_251 (Z_626 Z_630) resistor r=7.64642
    rZ_250 (Z_613 Z_609) resistor r=3.74715
    rZ_249 (Z_613 Z_571) resistor r=23.0973
    rZ_248 (Z_613 Z_569) resistor r=12.4893
    rZ_247 (Z_605 Z_609) resistor r=3.79301
    rZ_246 (Z_605 Z_565) resistor r=12.4893
    rZ_245 (Z_605 Z_563) resistor r=23.0464
    rZ_244 (Z_591 Z_587) resistor r=3.74715
    rZ_243 (Z_591 Z_559) resistor r=23.0973
    rZ_242 (Z_591 Z_557) resistor r=12.4893
    rZ_241 (Z_583 Z_587) resistor r=3.79301
    rZ_240 (Z_583 Z_553) resistor r=12.4893
    rZ_239 (Z_583 Z_551) resistor r=23.0464
    rZ_238 (Z_575 Z_695) resistor r=7.86393
    rZ_237 (Z_575 Z_645) resistor r=80.4635
    rZ_236 (Z_575 Z_547) resistor r=1.1774
    rZ_235 (Z_575 Z_500) resistor r=6.3017
    rZ_234 (Z_569 Z_571) resistor r=3.91249
    rZ_233 (Z_567 Z_609) resistor r=12.4893
    rZ_232 (Z_567 Z_569) resistor r=3.91249
    rZ_231 (Z_567 Z_526) resistor r=28.3474
    rZ_230 (Z_565 Z_567) resistor r=3.91249
    rZ_229 (Z_563 Z_565) resistor r=3.91249
    rZ_228 (Z_563 Z_522) resistor r=22.0284
    rZ_227 (Z_557 Z_559) resistor r=3.74437
    rZ_226 (Z_555 Z_587) resistor r=12.4893
    rZ_225 (Z_555 Z_557) resistor r=3.91249
    rZ_224 (Z_553 Z_555) resistor r=3.91249
    rZ_223 (Z_553 Z_513) resistor r=28.3474
    rZ_222 (Z_551 Z_553) resistor r=3.91249
    rZ_221 (Z_549 Z_706) resistor r=29.9127
    rZ_220 (Z_549 Z_660) resistor r=11.9867
    rZ_219 (Z_549 Z_506) resistor r=0.730263
    rZ_218 (Z_547 Z_706) resistor r=9.37082
    rZ_217 (Z_547 Z_549) resistor r=8.73113
    rZ_216 (Z_547 Z_506) resistor r=7.28926
    rZ_215 (Z_547 Z_500) resistor r=11.4982
    rZ_214 (Z_537 Z_692) resistor r=9.37082
    rZ_213 (Z_526 Z_571) resistor r=15.8581
    rZ_212 (Z_526 Z_569) resistor r=12.4893
    rZ_211 (Z_522 Z_567) resistor r=28.3474
    rZ_210 (Z_522 Z_565) resistor r=12.4893
    rZ_209 (Z_522 Z_526) resistor r=7.64642
    rZ_208 (Z_513 Z_559) resistor r=23.5046
    rZ_207 (Z_513 Z_557) resistor r=18.5113
    rZ_206 (Z_513 Z_555) resistor r=12.4893
    rZ_205 (Z_509 Z_553) resistor r=28.3474
    rZ_204 (Z_509 Z_551) resistor r=12.4893
    rZ_203 (Z_509 Z_513) resistor r=7.64642
    rZ_202 (Z_506 Z_464) resistor r=13.5364
    rZ_201 (Z_500 Z_645) resistor r=8.26874
    rZ_200 (Z_500 Z_506) resistor r=0.34245
    rZ_199 (Z_500 Z_464) resistor r=13.5364
    rZ_198 (Z_498 Z_537) resistor r=7.28926
    rZ_197 (Z_492 Z_630) resistor r=8.26661
    rZ_196 (Z_492 Z_537) resistor r=11.6215
    rZ_195 (Z_492 Z_498) resistor r=0.337608
    rZ_194 (Z_492 Z_462) resistor r=13.5364
    rZ_193 (Z_489 Z_551) resistor r=7.86393
    rZ_192 (Z_489 Z_509) resistor r=79.9826
    rZ_191 (Z_489 Z_475) resistor r=1.1774
    rZ_190 (Z_489 Z_454) resistor r=6.30745
    rZ_189 (Z_477 Z_563) resistor r=28.7465
    rZ_188 (Z_477 Z_522) resistor r=12.0271
    rZ_187 (Z_477 Z_460) resistor r=0.749072
    rZ_186 (Z_475 Z_563) resistor r=9.4563
    rZ_185 (Z_475 Z_477) resistor r=8.94723
    rZ_184 (Z_475 Z_460) resistor r=7.28926
    rZ_183 (Z_475 Z_454) resistor r=11.4982
    rZ_182 (Z_462 Z_498) resistor r=13.5364
    rZ_181 (Z_462 Z_464) resistor r=3.04251
    rZ_180 (Z_460 Z_387) resistor r=13.5364
    rZ_179 (Z_454 Z_509) resistor r=8.27933
    rZ_178 (Z_454 Z_460) resistor r=0.34245
    rZ_177 (Z_454 Z_387) resistor r=13.5364
    rZ_176 (Z_446 Z_442) resistor r=3.79301
    rZ_175 (Z_446 Z_398) resistor r=23.0464
    rZ_174 (Z_446 Z_396) resistor r=12.4893
    rZ_173 (Z_438 Z_442) resistor r=3.74715
    rZ_172 (Z_438 Z_392) resistor r=12.4893
    rZ_171 (Z_438 Z_390) resistor r=23.0973
    rZ_170 (Z_426 Z_430) resistor r=7.64642
    rZ_169 (Z_426 Z_396) resistor r=28.3474
    rZ_168 (Z_398 Z_430) resistor r=12.4893
    rZ_167 (Z_396 Z_430) resistor r=28.3474
    rZ_166 (Z_396 Z_398) resistor r=3.91249
    rZ_165 (Z_394 Z_442) resistor r=12.4893
    rZ_164 (Z_394 Z_426) resistor r=12.4893
    rZ_163 (Z_394 Z_396) resistor r=3.91249
    rZ_162 (Z_392 Z_426) resistor r=18.5113
    rZ_161 (Z_392 Z_394) resistor r=3.91249
    rZ_160 (Z_390 Z_426) resistor r=23.5046
    rZ_159 (Z_390 Z_392) resistor r=3.74437
    rZ_158 (Z_387 Z_464) resistor r=13.6119
    rZ_157 (Z_385 Z_462) resistor r=13.6119
    rZ_156 (Z_385 Z_387) resistor r=3.04251
    rZ_155 (Z_385 Z_376) resistor r=13.5364
    rZ_154 (Z_370 Z_385) resistor r=13.5364
    rZ_153 (Z_370 Z_376) resistor r=0.337608
    rZ_152 (Z_370 Z_368) resistor r=29.3329
    rZ_151 (Z_368 Z_398) resistor r=9.30356
    rZ_150 (Z_368 Z_376) resistor r=7.28926
    rZ_149 (Z_360 Z_370) resistor r=9.92117
    rZ_148 (Z_360 Z_368) resistor r=0.487999
    rZ_147 (Z_360 Z_346) resistor r=8.83119
    rZ_146 (Z_353 Z_357) resistor r=7.64642
    rZ_145 (Z_346 Z_357) resistor r=12.4893
    rZ_144 (Z_344 Z_357) resistor r=28.3474
    rZ_143 (Z_344 Z_353) resistor r=28.3474
    rZ_142 (Z_344 Z_346) resistor r=3.91249
    rZ_141 (Z_342 Z_353) resistor r=12.4893
    rZ_140 (Z_342 Z_344) resistor r=3.91249
    rZ_139 (Z_340 Z_353) resistor r=12.0223
    rZ_138 (Z_340 Z_342) resistor r=3.91249
    rZ_137 (Z_330 Z_346) resistor r=23.0464
    rZ_136 (Z_330 Z_344) resistor r=12.4893
    rZ_135 (Z_330 Z_326) resistor r=3.79301
    rZ_134 (Z_326 Z_342) resistor r=12.4893
    rZ_133 (Z_322 Z_340) resistor r=12.4893
    rZ_132 (Z_322 Z_326) resistor r=3.74715
    rZ_131 (Z_318 Z_353) resistor r=114.393
    rZ_130 (Z_318 Z_340) resistor r=18.2232
    rZ_129 (Z_318 Z_322) resistor r=4.40477
    rZ_128 (Z_228 Z_800) resistor r=6.77824
    rZ_127 (Z_228 Z_796) resistor r=15.5795
    rZ_126 (Z_228 Z_792) resistor r=6.73977
    rZ_125 (Z_228 Z_714) resistor r=46.5028
    rZ_124 (Z_228 Z_706) resistor r=46.5725
    rZ_123 (Z_227 Z_778) resistor r=6.77824
    rZ_122 (Z_227 Z_774) resistor r=15.5795
    rZ_121 (Z_227 Z_770) resistor r=6.73977
    rZ_120 (Z_227 Z_703) resistor r=46.5028
    rZ_119 (Z_227 Z_695) resistor r=46.5725
    rZ_118 (Z_226 Z_613) resistor r=6.77824
    rZ_117 (Z_226 Z_609) resistor r=15.5795
    rZ_116 (Z_226 Z_605) resistor r=6.73977
    rZ_115 (Z_226 Z_571) resistor r=46.5028
    rZ_114 (Z_226 Z_563) resistor r=46.5725
    rZ_113 (Z_226 XM3_d) resistor r=19.6459
    rZ_112 (Z_225 Z_591) resistor r=6.77824
    rZ_111 (Z_225 Z_587) resistor r=15.5795
    rZ_110 (Z_225 Z_583) resistor r=6.73977
    rZ_109 (Z_225 Z_559) resistor r=46.5028
    rZ_108 (Z_225 Z_551) resistor r=46.5725
    rZ_107 (Z_225 XM3_d) resistor r=19.6459
    rZ_106 (Z_224 Z_756) resistor r=6.73977
    rZ_105 (Z_224 Z_752) resistor r=15.5795
    rZ_104 (Z_224 Z_748) resistor r=6.77824
    rZ_103 (Z_224 Z_692) resistor r=46.5725
    rZ_102 (Z_224 Z_684) resistor r=46.5028
    rZ_101 (Z_224 XM1_d) resistor r=12.7787
    rZ_100 (Z_223 Z_736) resistor r=11.9602
    rZ_99 (Z_223 Z_732) resistor r=11.4807
    rZ_98 (Z_223 Z_728) resistor r=15.5795
    rZ_97 (Z_223 Z_724) resistor r=11.5529
    rZ_96 (Z_223 Z_720) resistor r=8.86831
    rZ_95 (Z_223 Z) resistor r=30.6873
    rZ_94 (Z_223 XM1_d) resistor r=12.7787
    rZ_93 (Z_222 Z_446) resistor r=6.73977
    rZ_92 (Z_222 Z_442) resistor r=15.5795
    rZ_91 (Z_222 Z_438) resistor r=6.77824
    rZ_90 (Z_222 Z_398) resistor r=46.5725
    rZ_89 (Z_222 Z_390) resistor r=46.5028
    rZ_88 (Z_221 Z_346) resistor r=46.5725
    rZ_87 (Z_221 Z_330) resistor r=6.73977
    rZ_86 (Z_221 Z_326) resistor r=15.5795
    rZ_85 (Z_221 Z_322) resistor r=11.5529
    rZ_84 (Z_221 Z_318) resistor r=8.86831
    rZ_83 (Z_189 Z_692) resistor r=91.5133
    rZ_82 (Z_189 Z_642) resistor r=6.81893
    rZ_81 (Z_189 Z_537) resistor r=8.73113
    rZ_80 (Z_189 Z_498) resistor r=0.753358
    rZ_79 (Z_181 Z_430) resistor r=6.81893
    rZ_78 (Z_181 Z_398) resistor r=94.037
    rZ_77 (Z_181 Z_376) resistor r=0.747972
    rZ_76 (Z_181 Z_368) resistor r=8.68353
    rZ_75 (Z_178 Z_370) resistor r=0.753358
    rZ_74 (Z_178 Z_360) resistor r=8.18584
    rZ_73 (Z_178 Z_357) resistor r=6.81893
    rZ_72 (Z_178 Z_346) resistor r=138.351
    rZ_71 (Z_150 Z_680) resistor r=7.86393
    rZ_70 (Z_150 Z_630) resistor r=80.5611
    rZ_69 (Z_150 Z_537) resistor r=1.19002
    rZ_68 (Z_150 Z_492) resistor r=6.2675
    rZ_67 (Z Z_736) resistor r=3.26642
    rZ_66 (XM2_d Z_228) resistor r=19.6459
    rZ_65 (XM2_d Z_227) resistor r=19.6459
    rZ_64 (XM0_d Z_222) resistor r=12.7787
    rZ_63 (XM0_d Z_221) resistor r=12.7787
    rS_50 (S_299 S_295) resistor r=5.74675
    rS_49 (S_280 S_256) resistor r=13.449
    rS_48 (S_264 S_299) resistor r=9.74939
    rS_47 (S_264 S_295) resistor r=17.5588
    rS_46 (S_248 S_280) resistor r=13.449
    rS_45 (S_248 S_256) resistor r=0.619491
    rS_44 (S_234 S_264) resistor r=7.55521
    rS_43 (S_234 S_248) resistor r=9.00287
    rS_42 (S_176 S_187) resistor r=0.619491
    rS_41 (S_176 S_150) resistor r=13.4658
    rS_40 (S_162 S_165) resistor r=0.304035
    rS_39 (S_150 S_187) resistor r=13.4658
    rS_38 (XM3_g S_299) resistor r=3040.78
    rS_37 (XM3_g S_295) resistor r=4093.06
    rS_36 (XM3_g S_280) resistor r=1960.91
    rS_35 (XM3_g S_264) resistor r=15884.4
    rS_34 (XM3_g S_256) resistor r=15884.4
    rS_33 (XM3_g S_248) resistor r=15884.4
    rS_32 (XM1_g S_187) resistor r=5504.31
    rS_31 (XM1_g S_176) resistor r=5504.31
    rS_30 (XM1_g S_165) resistor r=1615.42
    rS_29 (XM1_g S_162) resistor r=832.01
    rS_28 (XM1_g S_150) resistor r=679.301
    rS_27 (S_51 S_248) resistor r=9.00287
    rS_26 (S_51 S_234) resistor r=0.371936
    rS_25 (S_51 S_176) resistor r=35.6061
    rS_24 (S S_187) resistor r=0.856803
    rS_23 (S S_165) resistor r=11.2818
    rS_22 (XI0_MM2_g S_256) resistor r=2231.53
    rS_21 (XI0_MM2_g S_120) resistor r=1518.06
    rS_20 (XI0_MM1_g S_256) resistor r=841.353
    rS_19 (XI0_MM1_g XI0_MM2_g) resistor r=29761
    rS\'_44 (S\'_354 S\'_350) resistor r=5.74675
    rS\'_43 (S\'_340 S\'_336) resistor r=5.74675
    rS\'_42 (S\'_312 S\'_354) resistor r=9.74939
    rS\'_41 (S\'_312 S\'_350) resistor r=17.5588
    rS\'_40 (S\'_300 S\'_340) resistor r=9.74939
    rS\'_39 (S\'_300 S\'_336) resistor r=17.5588
    rS\'_38 (S\'_300 S\'_312) resistor r=260.052
    rS\'_37 (S\'_268 S\'_312) resistor r=8.06876
    rS\'_36 (S\'_268 S\'_300) resistor r=4.66424
    rS\'_35 (S\'_182 S\'_206) resistor r=5.00059
    rS\'_34 (S\'_179 S\'_182) resistor r=0.304035
    rS\'_33 (S\'_164 S\'_206) resistor r=7.55521
    rS\'_32 (XI0_MM2_d X5_noxref_s) resistor r=0.01
    rS\'_31 (XI0_MM1_d X3_noxref_s) resistor r=0.01
    rS\'_30 (XI0_MM1_d XI0_MM2_d) resistor r=709.951
    rS\'_29 (XM2_g S\'_354) resistor r=3040.78
    rS\'_28 (XM2_g S\'_350) resistor r=4093.06
    rS\'_27 (XM2_g S\'_340) resistor r=3040.78
    rS\'_26 (XM2_g S\'_336) resistor r=4093.06
    rS\'_25 (XM2_g S\'_312) resistor r=15884.4
    rS\'_24 (XM2_g S\'_300) resistor r=15884.4
    rS\'_23 (XM0_g S\'_182) resistor r=1615.42
    rS\'_22 (XM0_g S\'_179) resistor r=832.01
    rS\'_21 (XM0_g S\'_164) resistor r=549.298
    rS\'_20 (S\' S\'_268) resistor r=27.5554
    rS\'_19 (S\' S\'_206) resistor r=1.96623
    rS\'_18 (S\' S\'_182) resistor r=52.978
    rS\'_17 (S\' XI0_MM2_d) resistor r=185.209
    rS\'_16 (S\' XI0_MM1_d) resistor r=130.162
    rA_271 (A_629 A_625) resistor r=3.71123
    rA_270 (A_629 A_565) resistor r=12.4893
    rA_269 (A_621 A_625) resistor r=3.43745
    rA_268 (A_621 A_561) resistor r=12.4893
    rA_267 (A_617 A_621) resistor r=4.15999
    rA_266 (A_617 A_559) resistor r=12.4893
    rA_265 (A_617 A_557) resistor r=20.3209
    rA_264 (A_605 A_601) resistor r=3.9139
    rA_263 (A_605 A_552) resistor r=12.4893
    rA_262 (A_597 A_601) resistor r=3.62345
    rA_261 (A_597 A_548) resistor r=12.4893
    rA_260 (A_593 A_597) resistor r=4.38872
    rA_259 (A_593 A_546) resistor r=12.4893
    rA_258 (A_593 A_544) resistor r=20.7487
    rA_257 (A_583 A_579) resistor r=3.71123
    rA_256 (A_583 A_539) resistor r=12.4893
    rA_255 (A_575 A_579) resistor r=3.43745
    rA_254 (A_575 A_535) resistor r=12.4893
    rA_253 (A_571 A_575) resistor r=4.15999
    rA_252 (A_571 A_533) resistor r=12.4893
    rA_251 (A_571 A_531) resistor r=20.3209
    rA_250 (A_563 A_625) resistor r=12.4893
    rA_249 (A_563 A_565) resistor r=3.51803
    rA_248 (A_563 A_526) resistor r=28.1809
    rA_247 (A_561 A_563) resistor r=3.51803
    rA_246 (A_559 A_561) resistor r=3.51803
    rA_245 (A_559 A_522) resistor r=18.2403
    rA_244 (A_557 A_559) resistor r=3.3848
    rA_243 (A_557 A_522) resistor r=22.9172
    rA_242 (A_554 A_629) resistor r=20.3637
    rA_241 (A_554 A_565) resistor r=3.47792
    rA_240 (A_554 A_526) resistor r=23.485
    rA_239 (A_554 A_474) resistor r=6.7611
    rA_238 (A_550 A_601) resistor r=12.4893
    rA_237 (A_550 A_552) resistor r=3.91249
    rA_236 (A_550 A_513) resistor r=28.3474
    rA_235 (A_548 A_550) resistor r=3.91249
    rA_234 (A_546 A_548) resistor r=3.91249
    rA_233 (A_546 A_509) resistor r=18.5113
    rA_232 (A_544 A_546) resistor r=3.74437
    rA_231 (A_544 A_509) resistor r=23.5046
    rA_230 (A_541 A_552) resistor r=3.82165
    rA_229 (A_541 A_513) resistor r=24.3836
    rA_228 (A_541 A_468) resistor r=6.27118
    rA_227 (A_537 A_579) resistor r=12.4893
    rA_226 (A_537 A_539) resistor r=3.71733
    rA_225 (A_537 A_498) resistor r=28.1809
    rA_224 (A_535 A_537) resistor r=3.71733
    rA_223 (A_533 A_535) resistor r=3.71733
    rA_222 (A_533 A_494) resistor r=18.2403
    rA_221 (A_531 A_533) resistor r=3.5689
    rA_220 (A_531 A_494) resistor r=22.9172
    rA_219 (A_528 A_583) resistor r=20.3637
    rA_218 (A_528 A_539) resistor r=3.67209
    rA_217 (A_528 A_487) resistor r=12.4893
    rA_216 (A_528 A_481) resistor r=5.79607
    rA_215 (A_526 A_565) resistor r=12.4893
    rA_214 (A_522 A_563) resistor r=28.1809
    rA_213 (A_522 A_561) resistor r=12.4893
    rA_212 (A_522 A_526) resistor r=7.22562
    rA_211 (A_513 A_552) resistor r=12.4893
    rA_210 (A_509 A_550) resistor r=28.3474
    rA_209 (A_509 A_548) resistor r=12.4893
    rA_208 (A_509 A_513) resistor r=7.64642
    rA_207 (A_498 A_539) resistor r=12.4893
    rA_206 (A_494 A_537) resistor r=28.1809
    rA_205 (A_494 A_535) resistor r=12.4893
    rA_204 (A_494 A_498) resistor r=7.22562
    rA_203 (A_487 A_498) resistor r=3.16363
    rA_202 (A_481 A_487) resistor r=65.1207
    rA_201 (A_481 A_468) resistor r=1.14141
    rA_200 (A_481 A_440) resistor r=6.23467
    rA_199 (A_468 A_474) resistor r=0.409256
    rA_198 (A_448 A_474) resistor r=12.3798
    rA_197 (A_448 A_468) resistor r=7.28926
    rA_196 (A_440 A_487) resistor r=6.22363
    rA_195 (A_440 A_468) resistor r=12.0018
    rA_194 (A_440 A_448) resistor r=0.404542
    rA_193 (A_440 A_365) resistor r=5.96104
    rA_192 (A_434 A_361) resistor r=20.3209
    rA_191 (A_434 A_359) resistor r=12.4893
    rA_190 (A_430 A_434) resistor r=4.15999
    rA_189 (A_430 A_426) resistor r=3.43745
    rA_188 (A_430 A_357) resistor r=12.4893
    rA_187 (A_422 A_426) resistor r=3.71123
    rA_186 (A_422 A_353) resistor r=12.4893
    rA_185 (A_412 A_348) resistor r=20.7487
    rA_184 (A_412 A_346) resistor r=12.4893
    rA_183 (A_408 A_412) resistor r=4.38872
    rA_182 (A_408 A_404) resistor r=3.62345
    rA_181 (A_408 A_344) resistor r=12.4893
    rA_180 (A_400 A_404) resistor r=3.9139
    rA_179 (A_400 A_340) resistor r=12.4893
    rA_178 (A_390 A_361) resistor r=22.9172
    rA_177 (A_390 A_359) resistor r=18.2403
    rA_176 (A_386 A_390) resistor r=7.22562
    rA_175 (A_386 A_355) resistor r=28.1809
    rA_174 (A_377 A_348) resistor r=23.5046
    rA_173 (A_377 A_346) resistor r=18.5113
    rA_172 (A_373 A_377) resistor r=7.64642
    rA_171 (A_373 A_342) resistor r=28.3474
    rA_170 (A_365 A_448) resistor r=10.0728
    rA_169 (A_359 A_361) resistor r=3.3848
    rA_168 (A_357 A_390) resistor r=12.4893
    rA_167 (A_357 A_359) resistor r=3.51803
    rA_166 (A_355 A_426) resistor r=12.4893
    rA_165 (A_355 A_390) resistor r=28.1809
    rA_164 (A_355 A_357) resistor r=3.51803
    rA_163 (A_353 A_386) resistor r=12.4893
    rA_162 (A_353 A_355) resistor r=3.51803
    rA_161 (A_350 A_422) resistor r=20.3637
    rA_160 (A_350 A_386) resistor r=23.485
    rA_159 (A_350 A_353) resistor r=3.47792
    rA_158 (A_350 A_326) resistor r=24.5288
    rA_157 (A_346 A_348) resistor r=3.74437
    rA_156 (A_344 A_377) resistor r=12.4893
    rA_155 (A_344 A_346) resistor r=3.91249
    rA_154 (A_342 A_404) resistor r=12.4893
    rA_153 (A_342 A_377) resistor r=28.3474
    rA_152 (A_342 A_344) resistor r=3.91249
    rA_151 (A_340 A_373) resistor r=12.4893
    rA_150 (A_340 A_342) resistor r=3.91249
    rA_149 (A_337 A_400) resistor r=20.794
    rA_148 (A_337 A_373) resistor r=24.3836
    rA_147 (A_337 A_340) resistor r=3.82165
    rA_146 (A_337 A_325) resistor r=26.1564
    rA_145 (A_326 A_386) resistor r=9.48638
    rA_144 (A_325 A_373) resistor r=9.32794
    rA_143 (A_325 A_307) resistor r=0.481215
    rA_142 (A_320 A_365) resistor r=26.2647
    rA_141 (A_307 A_326) resistor r=1.1367
    rA_140 (A_307 A_320) resistor r=10.0728
    rA_139 (A_299 A_320) resistor r=5.96104
    rA_138 (A_299 A_307) resistor r=0.404542
    rA_137 (A_299 A_297) resistor r=0.696641
    rA_136 (A_299 A_281) resistor r=9.87494
    rA_135 (A_297 A_281) resistor r=8.21966
    rA_134 (A_297 A_271) resistor r=9.48638
    rA_133 (A_295 A_350) resistor r=6.7611
    rA_132 (A_295 A_326) resistor r=6.09397
    rA_131 (A_295 A_307) resistor r=12.3798
    rA_130 (A_289 A_337) resistor r=6.27118
    rA_129 (A_289 A_325) resistor r=8.35328
    rA_128 (A_289 A_307) resistor r=7.28926
    rA_127 (A_289 A_299) resistor r=29.7516
    rA_126 (A_289 A_295) resistor r=0.409256
    rA_125 (A_289 A_281) resistor r=0.494965
    rA_124 (A_271 A_275) resistor r=7.22562
    rA_123 (A_266 A_275) resistor r=22.9172
    rA_122 (A_264 A_275) resistor r=18.2403
    rA_121 (A_264 A_266) resistor r=3.5689
    rA_120 (A_262 A_275) resistor r=12.4893
    rA_119 (A_262 A_264) resistor r=3.71733
    rA_118 (A_260 A_275) resistor r=28.1809
    rA_117 (A_260 A_271) resistor r=28.1809
    rA_116 (A_260 A_262) resistor r=3.71733
    rA_115 (A_258 A_271) resistor r=12.4893
    rA_114 (A_258 A_260) resistor r=3.71733
    rA_113 (A_255 A_297) resistor r=28.2866
    rA_112 (A_255 A_281) resistor r=6.53587
    rA_111 (A_255 A_271) resistor r=23.485
    rA_110 (A_255 A_258) resistor r=3.67209
    rA_109 (A_255 A_237) resistor r=20.3637
    rA_108 (A_249 A_266) resistor r=20.3209
    rA_107 (A_249 A_264) resistor r=12.4893
    rA_106 (A_245 A_262) resistor r=12.4893
    rA_105 (A_245 A_249) resistor r=4.15999
    rA_104 (A_245 A_241) resistor r=3.43745
    rA_103 (A_241 A_260) resistor r=12.4893
    rA_102 (A_237 A_258) resistor r=12.4893
    rA_101 (A_237 A_241) resistor r=3.71123
    rA_100 (A_166 A_629) resistor r=7.60619
    rA_99 (A_166 A_625) resistor r=15.4957
    rA_98 (A_166 A_621) resistor r=11.7021
    rA_97 (A_166 A_617) resistor r=7.41083
    rA_96 (A_166 A_557) resistor r=68.9237
    rA_95 (A_166 A_554) resistor r=68.7687
    rA_94 (A_165 A_605) resistor r=12.349
    rA_93 (A_165 A_601) resistor r=15.5228
    rA_92 (A_165 A_597) resistor r=11.7129
    rA_91 (A_165 A_593) resistor r=7.46815
    rA_90 (A_165 A_544) resistor r=66.7567
    rA_89 (A_165 A_541) resistor r=292.017
    rA_88 (A_164 A_583) resistor r=7.60619
    rA_87 (A_164 A_579) resistor r=15.4957
    rA_86 (A_164 A_575) resistor r=11.7021
    rA_85 (A_164 A_571) resistor r=7.41083
    rA_84 (A_164 A_531) resistor r=68.9237
    rA_83 (A_164 A_528) resistor r=68.7687
    rA_82 (A_163 A_434) resistor r=7.41083
    rA_81 (A_163 A_430) resistor r=11.7021
    rA_80 (A_163 A_426) resistor r=15.4957
    rA_79 (A_163 A_422) resistor r=7.60619
    rA_78 (A_163 A_361) resistor r=68.9237
    rA_77 (A_163 A_350) resistor r=68.7687
    rA_76 (A_163 XM0_s) resistor r=12.7787
    rA_75 (A_162 A_412) resistor r=7.46815
    rA_74 (A_162 A_408) resistor r=11.7129
    rA_73 (A_162 A_404) resistor r=15.5228
    rA_72 (A_162 A_400) resistor r=7.66576
    rA_71 (A_162 A_348) resistor r=66.7567
    rA_70 (A_162 A_337) resistor r=66.6106
    rA_69 (A_161 A_266) resistor r=68.9237
    rA_68 (A_161 A_255) resistor r=68.7687
    rA_67 (A_161 A_249) resistor r=7.41083
    rA_66 (A_161 A_245) resistor r=11.7021
    rA_65 (A_161 A_241) resistor r=15.4957
    rA_64 (A_161 A_237) resistor r=7.60619
    rA_63 (A_161 XM0_s) resistor r=12.7787
    rA_62 (A_150 A_554) resistor r=24.5288
    rA_61 (A_150 A_526) resistor r=9.48638
    rA_60 (A_150 A_474) resistor r=6.09397
    rA_59 (A_150 A_448) resistor r=1.1367
    rA_58 (A_146 A_541) resistor r=26.1564
    rA_57 (A_146 A_513) resistor r=9.32794
    rA_56 (A_146 A_468) resistor r=8.35328
    rA_55 (A_146 A_448) resistor r=0.481215
    rA_54 (A A_605) resistor r=3.30173
    rA_53 (A A_541) resistor r=14.0957
    rA_52 (A A_165) resistor r=13.7022
    rA_51 (XM3_s A_166) resistor r=19.6459
    rA_50 (XM3_s A_165) resistor r=19.6459
    rA_49 (XM3_s A_164) resistor r=19.6459
    rA_48 (XM0_s A_162) resistor r=12.7787
    rnoxref_14_5 (noxref_14 X5_noxref_g) resistor r=0.01
    rnoxref_14_4 (noxref_14 noxref_14_4) resistor r=1870.72
    rnoxref_14_3 (noxref_14 noxref_14_3) resistor r=1518.06
    rnoxref_13_5 (noxref_13 X4_noxref_g) resistor r=0.01
    rnoxref_13_4 (noxref_13 noxref_13_4) resistor r=1870.72
    rnoxref_13_3 (noxref_13 noxref_13_3) resistor r=1518.06
    rnoxref_8_3 (noxref_8 X3_noxref_g) resistor r=0.01
    rnoxref_8_2 (noxref_8 noxref_8_4) resistor r=645.736
    rnoxref_7_3 (noxref_7 X2_noxref_g) resistor r=0.01
    rnoxref_7_2 (noxref_7 noxref_7_4) resistor r=645.736
    rVSS_188 (XI0_MM1_s X2_noxref_s) resistor r=0.01
    rVSS_187 (VSS_1200 VSS_1204) resistor r=0.572245
    rVSS_186 (VSS_1196 VSS_1200) resistor r=0.572245
    rVSS_185 (VSS_1192 VSS_1196) resistor r=0.572245
    rVSS_184 (VSS_1188 VSS_1192) resistor r=0.572245
    rVSS_183 (VSS_1188 VSS_965) resistor r=16.4261
    rVSS_182 (VSS_1186 VSS_1188) resistor r=1.28212
    rVSS_181 (VSS_1122 VSS_1126) resistor r=0.572245
    rVSS_180 (VSS_1118 VSS_1122) resistor r=0.572245
    rVSS_179 (VSS_1114 VSS_1118) resistor r=0.572245
    rVSS_178 (VSS_1110 VSS_1114) resistor r=0.572245
    rVSS_177 (VSS_1106 VSS_1186) resistor r=13.6371
    rVSS_176 (VSS_1106 VSS_1110) resistor r=0.572245
    rVSS_175 (VSS_1106 VSS_862) resistor r=16.4261
    rVSS_174 (VSS_1088 VSS_1092) resistor r=0.572245
    rVSS_173 (VSS_1084 VSS_1088) resistor r=0.572245
    rVSS_172 (VSS_1080 VSS_1084) resistor r=0.572245
    rVSS_171 (VSS_1076 VSS_1080) resistor r=0.572245
    rVSS_170 (VSS_1076 VSS_831) resistor r=16.4261
    rVSS_169 (VSS_1074 VSS_1076) resistor r=1.28212
    rVSS_168 (VSS_1045 VSS_1126) resistor r=14.4607
    rVSS_167 (VSS_1045 VSS_1019) resistor r=1.45751
    rVSS_166 (VSS_1019 VSS_1015) resistor r=1.58711
    rVSS_165 (VSS_1011 VSS_1015) resistor r=0.572245
    rVSS_164 (VSS_1007 VSS_1011) resistor r=0.572245
    rVSS_163 (VSS_995 VSS_1074) resistor r=13.6371
    rVSS_162 (VSS_995 VSS_999) resistor r=0.572245
    rVSS_161 (VSS_995 VSS_728) resistor r=16.4261
    rVSS_160 (VSS_983 VSS_1204) resistor r=12.1522
    rVSS_159 (VSS_981 VSS_1204) resistor r=20.7905
    rVSS_158 (VSS_981 VSS_983) resistor r=7.59916
    rVSS_157 (VSS_979 VSS_1204) resistor r=41.8652
    rVSS_156 (VSS_979 VSS_1200) resistor r=41.8652
    rVSS_155 (VSS_979 VSS_981) resistor r=5.69937
    rVSS_154 (VSS_975 VSS_1200) resistor r=20.7905
    rVSS_153 (VSS_975 VSS_979) resistor r=7.66477
    rVSS_152 (VSS_973 VSS_1200) resistor r=41.8652
    rVSS_151 (VSS_973 VSS_1196) resistor r=41.8652
    rVSS_150 (VSS_973 VSS_975) resistor r=5.69937
    rVSS_149 (VSS_971 VSS_1196) resistor r=20.7905
    rVSS_148 (VSS_971 VSS_973) resistor r=7.59916
    rVSS_147 (VSS_969 VSS_1196) resistor r=41.8652
    rVSS_146 (VSS_969 VSS_1192) resistor r=41.8652
    rVSS_145 (VSS_969 VSS_971) resistor r=5.69937
    rVSS_144 (VSS_967 VSS_1192) resistor r=20.7905
    rVSS_143 (VSS_967 VSS_969) resistor r=5.69937
    rVSS_142 (VSS_965 VSS_1192) resistor r=41.8652
    rVSS_141 (VSS_965 VSS_967) resistor r=7.59916
    rVSS_140 (VSS_880 VSS_1126) resistor r=16.4051
    rVSS_139 (VSS_880 VSS_1122) resistor r=41.8652
    rVSS_138 (VSS_878 VSS_1122) resistor r=20.7905
    rVSS_137 (VSS_878 VSS_880) resistor r=7.59916
    rVSS_136 (VSS_876 VSS_1122) resistor r=41.8652
    rVSS_135 (VSS_876 VSS_1118) resistor r=41.8652
    rVSS_134 (VSS_876 VSS_878) resistor r=5.69937
    rVSS_133 (VSS_872 VSS_1118) resistor r=20.7905
    rVSS_132 (VSS_872 VSS_876) resistor r=7.66477
    rVSS_131 (VSS_870 VSS_1118) resistor r=41.8652
    rVSS_130 (VSS_870 VSS_1114) resistor r=41.8652
    rVSS_129 (VSS_870 VSS_872) resistor r=5.69937
    rVSS_128 (VSS_868 VSS_1114) resistor r=20.7905
    rVSS_127 (VSS_868 VSS_870) resistor r=7.59916
    rVSS_126 (VSS_866 VSS_1114) resistor r=41.8652
    rVSS_125 (VSS_866 VSS_1110) resistor r=41.8652
    rVSS_124 (VSS_866 VSS_868) resistor r=5.69937
    rVSS_123 (VSS_864 VSS_1110) resistor r=20.7905
    rVSS_122 (VSS_864 VSS_866) resistor r=5.69937
    rVSS_121 (VSS_862 VSS_1110) resistor r=41.8652
    rVSS_120 (VSS_862 VSS_864) resistor r=7.59916
    rVSS_119 (VSS_849 VSS_1092) resistor r=12.1522
    rVSS_118 (VSS_847 VSS_1092) resistor r=20.7905
    rVSS_117 (VSS_847 VSS_849) resistor r=7.59916
    rVSS_116 (VSS_845 VSS_1092) resistor r=41.8652
    rVSS_115 (VSS_845 VSS_1088) resistor r=41.8652
    rVSS_114 (VSS_845 VSS_847) resistor r=5.69937
    rVSS_113 (VSS_841 VSS_1088) resistor r=20.7905
    rVSS_112 (VSS_841 VSS_845) resistor r=7.66477
    rVSS_111 (VSS_839 VSS_1088) resistor r=41.8652
    rVSS_110 (VSS_839 VSS_1084) resistor r=41.8652
    rVSS_109 (VSS_839 VSS_841) resistor r=5.69937
    rVSS_108 (VSS_837 VSS_1084) resistor r=20.7905
    rVSS_107 (VSS_837 VSS_839) resistor r=7.59916
    rVSS_106 (VSS_835 VSS_1084) resistor r=41.8652
    rVSS_105 (VSS_835 VSS_1080) resistor r=41.8652
    rVSS_104 (VSS_835 VSS_837) resistor r=5.69937
    rVSS_103 (VSS_833 VSS_1080) resistor r=20.7905
    rVSS_102 (VSS_833 VSS_835) resistor r=5.69937
    rVSS_101 (VSS_831 VSS_1080) resistor r=41.8652
    rVSS_100 (VSS_831 VSS_833) resistor r=7.59916
    rVSS_99 (VSS_746 VSS_1015) resistor r=16.4051
    rVSS_98 (VSS_746 VSS_1011) resistor r=41.8652
    rVSS_97 (VSS_744 VSS_1011) resistor r=20.7905
    rVSS_96 (VSS_744 VSS_746) resistor r=7.59916
    rVSS_95 (VSS_742 VSS_1011) resistor r=41.8652
    rVSS_94 (VSS_742 VSS_1007) resistor r=41.8652
    rVSS_93 (VSS_742 VSS_744) resistor r=5.69937
    rVSS_92 (VSS_738 VSS_1007) resistor r=20.7905
    rVSS_91 (VSS_738 VSS_742) resistor r=7.66477
    rVSS_90 (VSS_736 VSS_1007) resistor r=41.8652
    rVSS_89 (VSS_736 VSS_738) resistor r=5.69937
    rVSS_88 (VSS_734 VSS_736) resistor r=7.59916
    rVSS_87 (VSS_734 VSS_732) resistor r=5.69937
    rVSS_86 (VSS_732 VSS_999) resistor r=41.8652
    rVSS_85 (VSS_730 VSS_999) resistor r=20.7905
    rVSS_84 (VSS_730 VSS_732) resistor r=5.69937
    rVSS_83 (VSS_728 VSS_999) resistor r=41.8652
    rVSS_82 (VSS_728 VSS_730) resistor r=7.59916
    rVSS_81 (X2_noxref_s VSS_1045) resistor r=157.266
    rVSS_80 (X2_noxref_s VSS_1019) resistor r=1281.09
    rVSS_79 (VSS VSS_1007) resistor r=0.572245
    rVSS_78 (VSS VSS_999) resistor r=0.572245
    rVSS_77 (VSS VSS_736) resistor r=41.8652
    rVSS_76 (VSS VSS_734) resistor r=20.7905
    rVSS_75 (VSS VSS_732) resistor r=41.8652
    rVSS_74 (X2_noxref_b VSS_1204) resistor r=67.6288
    rVSS_73 (X2_noxref_b VSS_1188) resistor r=1043.1
    rVSS_72 (X2_noxref_b VSS_1186) resistor r=10.4451
    rVSS_71 (X2_noxref_b VSS_1126) resistor r=9.19293
    rVSS_70 (X2_noxref_b VSS_1106) resistor r=13.842
    rVSS_69 (X2_noxref_b VSS_1092) resistor r=67.6288
    rVSS_68 (X2_noxref_b VSS_1076) resistor r=1043.1
    rVSS_67 (X2_noxref_b VSS_1074) resistor r=10.4451
    rVSS_66 (X2_noxref_b VSS_1045) resistor r=7.04894
    rVSS_65 (X2_noxref_b VSS_1019) resistor r=74.8947
    rVSS_64 (X2_noxref_b VSS_1015) resistor r=424.093
    rVSS_63 (X2_noxref_b VSS_995) resistor r=13.842
    rVSS_62 (X2_noxref_b VSS_983) resistor r=76.2993
    rVSS_61 (X2_noxref_b VSS_981) resistor r=110.032
    rVSS_60 (X2_noxref_b VSS_979) resistor r=147.129
    rVSS_59 (X2_noxref_b VSS_975) resistor r=147.129
    rVSS_58 (X2_noxref_b VSS_973) resistor r=110.032
    rVSS_57 (X2_noxref_b VSS_971) resistor r=110.032
    rVSS_56 (X2_noxref_b VSS_969) resistor r=220.064
    rVSS_55 (X2_noxref_b VSS_967) resistor r=110.032
    rVSS_54 (X2_noxref_b VSS_965) resistor r=79.4715
    rVSS_53 (X2_noxref_b VSS_880) resistor r=79.4251
    rVSS_52 (X2_noxref_b VSS_878) resistor r=110.032
    rVSS_51 (X2_noxref_b VSS_876) resistor r=147.129
    rVSS_50 (X2_noxref_b VSS_872) resistor r=147.129
    rVSS_49 (X2_noxref_b VSS_870) resistor r=110.032
    rVSS_48 (X2_noxref_b VSS_868) resistor r=110.032
    rVSS_47 (X2_noxref_b VSS_866) resistor r=220.064
    rVSS_46 (X2_noxref_b VSS_864) resistor r=110.032
    rVSS_45 (X2_noxref_b VSS_862) resistor r=79.4715
    rVSS_44 (X2_noxref_b VSS_849) resistor r=76.2993
    rVSS_43 (X2_noxref_b VSS_847) resistor r=110.032
    rVSS_42 (X2_noxref_b VSS_845) resistor r=147.129
    rVSS_41 (X2_noxref_b VSS_841) resistor r=147.129
    rVSS_40 (X2_noxref_b VSS_839) resistor r=110.032
    rVSS_39 (X2_noxref_b VSS_837) resistor r=110.032
    rVSS_38 (X2_noxref_b VSS_835) resistor r=220.064
    rVSS_37 (X2_noxref_b VSS_833) resistor r=110.032
    rVSS_36 (X2_noxref_b VSS_831) resistor r=79.4715
    rVSS_35 (X2_noxref_b VSS_746) resistor r=79.4251
    rVSS_34 (X2_noxref_b VSS_744) resistor r=110.032
    rVSS_33 (X2_noxref_b VSS_742) resistor r=147.129
    rVSS_32 (X2_noxref_b VSS_738) resistor r=147.129
    rVSS_31 (X2_noxref_b VSS_736) resistor r=110.032
    rVSS_30 (X2_noxref_b VSS_734) resistor r=110.032
    rVSS_29 (X2_noxref_b VSS_732) resistor r=220.064
    rVSS_28 (X2_noxref_b VSS_730) resistor r=110.032
    rVSS_27 (X2_noxref_b VSS_728) resistor r=79.4715
    rVSS_26 (X2_noxref_b X3_noxref_b) resistor r=0.01
    rVSS_25 (X2_noxref_b XI0_MM1_b) resistor r=0.01
    rVSS_24 (X2_noxref_b XM1_b) resistor r=0.01
    rVSS_23 (X2_noxref_b XM0_b) resistor r=0.01
    XI0_MM1 (XI0_MM1_d XI0_MM1_g XI0_MM1_s XI0_MM1_b) nch_ulvt_mac \
        l=1.6e-08 nfin=5 w=202.00n multi=1 nf=1 sd=74.0n ad=7.474e-15 \
        as=7.474e-15 pd=2.76e-07 ps=2.76e-07 nrd=0 nrs=0 sa=9e-08 sb=9e-08 \
        sca=9.8885 scb=0.0130491 scc=0.000533259 sa1=9e-08 sa2=9e-08 \
        sa3=9e-08 sb1=9e-08 sb2=9e-08 sb3=9e-08 ploda1=1.6e-08 ploda2=0 \
        ploda3=0 plodb1=1.6e-08 plodb2=0 plodb3=0 sodxa=1.491e-05 \
        sodxb=3.77583e-06 sa5=9e-08 sa6=9e-08 sb5=9e-08 sb6=9e-08 \
        sa7=9e-08 sb7=9e-08 sodxa1=8.13445e-07 sodxa2=1.47415e-06 \
        sodxa4=1.88534e-07 sodxb1=5.14644e-07 sodxb2=1.21152e-06 \
        sodxb4=1.54946e-07 sodyb=3e-06 sodyt=6.14e-07 dfm_flag=1 ojh=0 \
        nf_flag=0 ccosflag=0 ccodflag=0 rcosflag=0 rcodflag=0 rgflag=0 \
        smbt=1e+06 smbb=1e+06 dinsaflag=0 edgeflag=0 matchingflag=0 \
        ppitch=0 spot=1.66e-07 spob=3.5e-08 spotl1=1.66e-07 spobl1=3.5e-08 \
        spotl2=1.66e-07 spobl2=3.5e-08 spotr1=1.66e-07 spobr1=3.5e-08 \
        spotr2=1.66e-07 spobr2=3.5e-08
    XI0_MM2 (XI0_MM2_d XI0_MM2_g VDD VDD) pch_ulvt_mac l=1.6e-08 nfin=5 \
        w=202.00n multi=1 nf=1 sd=74.0n ad=7.474e-15 as=7.474e-15 \
        pd=2.76e-07 ps=2.76e-07 nrd=0 nrs=0 sa=9e-08 sb=9e-08 sca=31.7423 \
        scb=0.0300136 scc=0.00507157 sa1=9e-08 sa2=9e-08 sa3=9e-08 \
        sb1=9e-08 sb2=9e-08 sb3=9e-08 ploda1=1.6e-08 ploda2=0 ploda3=0 \
        plodb1=1.6e-08 plodb2=0 plodb3=0 sodxa=1.491e-05 sodxb=3.77583e-06 \
        sa5=9e-08 sa6=9e-08 sb5=9e-08 sb6=9e-08 sa7=9e-08 sb7=9e-08 \
        sodxa1=8.13445e-07 sodxa2=1.47415e-06 sodxa4=1.88534e-07 \
        sodxb1=5.14644e-07 sodxb2=1.21152e-06 sodxb4=1.54946e-07 \
        sodyb=6.14e-07 sodyt=3e-06 dfm_flag=1 ojh=0 nf_flag=0 ccosflag=0 \
        ccodflag=0 rcosflag=0 rcodflag=0 rgflag=0 smbt=1e+06 smbb=1e+06 \
        dinsaflag=0 edgeflag=0 matchingflag=0 ppitch=0 spot=3.5e-08 \
        spob=1.82e-07 spotl1=3.5e-08 spobl1=1.82e-07 spotl2=3.5e-08 \
        spobl2=1.82e-07 spotr1=3.5e-08 spobr1=1.82e-07 spotr2=3.5e-08 \
        spobr2=1.82e-07
    X3_noxref (X3_noxref_s X3_noxref_g X3_noxref_b) npode_ulvt_mac \
        l=1.6e-08 nfin=5 w=58n m=1 as=7.474e-15 ps=2.76e-07 dfm_flag=1 \
        ccopflag=0 rcopflag=0 rgpflag=0
    X2_noxref (X2_noxref_s X2_noxref_g X2_noxref_b) npode_ulvt_mac \
        l=1.6e-08 nfin=5 w=58n m=1 as=7.474e-15 ps=2.76e-07 dfm_flag=1 \
        ccopflag=0 rcopflag=0 rgpflag=0
    X5_noxref (X5_noxref_s X5_noxref_g VDD) ppode_ulvt_mac l=1.6e-08 \
        nfin=5 w=58n m=1 as=7.474e-15 ps=2.76e-07 dfm_flag=1 ccopflag=0 \
        rcopflag=0 rgpflag=0
    X4_noxref (VDD X4_noxref_g VDD) ppode_ulvt_mac l=1.6e-08 nfin=5 w=58n \
        m=1 as=7.474e-15 ps=2.76e-07 dfm_flag=1 ccopflag=0 rcopflag=0 \
        rgpflag=0
    XM1 (XM1_d XM1_g XM1_s XM1_b) nmos_rf_ulvt_nw multi=1 cbflag=2 \
        dinsaflag=0 lr=1.6e-08 nfin=20 ngcon=2 nr=4 ppitch=0 rcmflag=0 \
        sa=182.00n sb=182.00n sc_b=1.243e-06 sc_l=5.111e-06 sc_r=1.468e-06 \
        sc_t=1.171e-06 sd=74.0n sobe=7.24e-07 sobn=8.06e-07 sobs=8.06e-07 \
        sobw=7.24e-07 odnum_rf=1 wr=922.00n
    XM0 (XM0_d XM0_g XM0_s XM0_b) nmos_rf_ulvt_nw multi=1 cbflag=2 \
        dinsaflag=0 lr=1.6e-08 nfin=20 ngcon=2 nr=4 ppitch=0 rcmflag=0 \
        sa=182.00n sb=182.00n sc_b=1.243e-06 sc_l=2.299e-06 sc_r=4.28e-06 \
        sc_t=1.171e-06 sd=74.0n sobe=7.24e-07 sobn=8.06e-07 sobs=8.06e-07 \
        sobw=7.24e-07 odnum_rf=1 wr=922.00n
    XM2 (XM2_d XM2_g XM2_s VDD) pmos_rf_ulvt_nw multi=1 cbflag=2 \
        dinsaflag=0 lr=1.6e-08 nfin=20 ngcon=2 nr=4 ppitch=0 rcmflag=0 \
        sa=182.00n sb=182.00n sc_b=1.099e-06 sc_l=4.215e-06 sc_r=1.403e-06 \
        sc_t=1.099e-06 sd=74.0n sobe=7.24e-07 sobn=8.06e-07 sobs=8.06e-07 \
        sobw=7.24e-07 odnum_rf=1 wr=922.00n
    XM3 (XM3_d XM3_g XM3_s VDD) pmos_rf_ulvt_nw multi=1 cbflag=2 \
        dinsaflag=0 lr=1.6e-08 nfin=20 ngcon=2 nr=4 ppitch=0 rcmflag=0 \
        sa=182.00n sb=182.00n sc_b=1.099e-06 sc_l=1.403e-06 sc_r=4.215e-06 \
        sc_t=1.099e-06 sd=74.0n sobe=7.24e-07 sobn=8.06e-07 sobs=8.06e-07 \
        sobw=7.24e-07 odnum_rf=1 wr=922.00n
ends Thesis_Tapeout_2_1_MUX_calibre_rcc
// End of subcircuit definition.

// Library name: Thesis_Tapeout
// Cell name: MUX_C_Load
// View name: schematic
I1 (net3 net2 net1 net6 0 net4) Thesis_Tapeout_2_1_MUX_calibre_rcc
V3 (net2 0) vsource dc=0 type=dc
V1 (net1 0) vsource dc=0 type=dc
V0 (net6 0) vsource dc=800.0m type=dc
V2 (net3 0) vsource mag=800.0m type=sine freq=10G
simulatorOptions options psfversion="1.4.0" reltol=1e-3 vabstol=1e-6 \
    iabstol=1e-12 temp=27 tnom=27 scalem=1.0 scale=1.0 gmin=1e-12 rforce=1 \
    maxnotes=5 maxwarns=5 digits=5 cols=80 pivrel=1e-3 \
    sensfile="../psf/sens.output" checklimitdest=psf
tran tran stop=1n errpreset=liberal write="spectre.ic" \
    writefinal="spectre.fc" annotate=status maxiters=5
finalTimeOP info what=oppoint where=rawfile
modelParameter info what=models where=rawfile
element info what=inst where=rawfile
outputParameter info what=output where=rawfile
designParamVals info what=parameters where=rawfile
primitives info what=primitives where=rawfile
subckts info what=subckts where=rawfile
save V2:p
saveOptions options save=allpub
